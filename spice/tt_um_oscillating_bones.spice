* NGSPICE file created from tt_um_oscillating_bones.ext - technology: ihp-sg13g2

.subckt tt_um_oscillating_bones ena clk rst_n ui_in[0] ui_in[1] ui_in[2] ui_in[3]
+ ui_in[4] ui_in[5] ui_in[6] ui_in[7] uio_in[0] uio_in[1] uio_in[2] uio_in[3] uio_in[4]
+ uio_in[5] uio_in[6] uio_in[7] uo_out[0] uo_out[1] uo_out[2] uo_out[3] uo_out[4]
+ uo_out[5] uo_out[6] uo_out[7] uio_out[0] uio_out[1] uio_out[2] uio_out[3] uio_out[4]
+ uio_out[5] uio_out[6] uio_out[7] uio_oe[0] uio_oe[1] uio_oe[2] uio_oe[3] uio_oe[4]
+ uio_oe[5] uio_oe[6] uio_oe[7] VGND VDPWR
X0 uo_out[1].t1 a_22205_61585# VGND.t114 VGND.t113 sg13_lv_nmos ad=0.1406p pd=1.12u as=0.2516p ps=2.16u w=0.74u l=0.13u
X1 VDPWR.t28 a_16367_61578# freq_divider_0.sg13g2_dfrbp_2_0.D VDPWR.t0 sg13_lv_pmos ad=0.2014p pd=1.53u as=0.2128p ps=1.5u w=1.12u l=0.13u
X2 VGND.t59 a_17996_61559# a_17075_61640# VGND.t58 sg13_lv_nmos ad=0.1626p pd=1.415u as=0.2516p ps=2.16u w=0.74u l=0.13u
X3 VGND.t75 freq_divider_0.sg13g2_dfrbp_2_0.RESET_B a_21132_61704# VGND.t74 sg13_lv_nmos ad=0.1701p pd=1.65u as=38.85f ps=0.605u w=0.42u l=0.13u
X4 a_16707_61717# a_16367_61578# VDPWR.t28 VDPWR.t0 sg13_lv_pmos ad=79.8f pd=0.8u as=0.2014p ps=1.53u w=0.42u l=0.13u
X5 a_17910_61326# freq_divider_0.sg13g2_dfrbp_2_0.RESET_B VDPWR.t18 VDPWR.t0 sg13_lv_pmos ad=79.8f pd=0.8u as=0.36237p ps=2.605u w=0.42u l=0.13u
X6 a_20876_61559# freq_divider_0.sg13g2_dfrbp_2_0.RESET_B VDPWR.t23 VDPWR.t0 sg13_lv_pmos ad=0.147p pd=1.54u as=0.1563p ps=1.22u w=0.42u l=0.13u
X7 ring_0/inverter_ring_0/skullfet_inverter_19.A ring_0/inverter_ring_0/skullfet_inverter_0.Y ring_0/inverter_ring_0/skullfet_inverter_0.VDPWR ring_0/inverter_ring_0/skullfet_inverter_0.VDPWR sg13_lv_pmos ad=6.2694p pd=26.64u as=4.4307p ps=10.9u w=4.05u l=0.4u
X8 VGND.t22 a_22511_61578# a_22205_61585# VGND.t26 sg13_lv_nmos ad=0.1331p pd=1.12u as=0.2176p ps=1.96u w=0.64u l=0.13u
X9 VGND.t73 freq_divider_0.sg13g2_dfrbp_2_0.RESET_B a_18252_61704# VGND.t72 sg13_lv_nmos ad=0.1701p pd=1.65u as=38.85f ps=0.605u w=0.42u l=0.13u
X10 ring_0/inverter_ring_0/skullfet_inverter_6.A ring_0/inverter_ring_0/skullfet_inverter_7.A ring_0/inverter_ring_0/skullfet_inverter_0.VDPWR ring_0/inverter_ring_0/skullfet_inverter_0.VDPWR sg13_lv_pmos ad=6.2694p pd=26.64u as=4.4307p ps=10.9u w=4.05u l=0.4u
X11 VGND.t99 ring_0/inverter_ring_0/skullfet_inverter_13.A ring_0/inverter_ring_0/skullfet_inverter_12.A VGND.t98 sg13_lv_nmos ad=4.2687p pd=10.82u as=6.4314p ps=26.72u w=4.05u l=0.4u
X12 VDPWR.t15 a_20876_61559# a_19955_61640# VDPWR.t0 sg13_lv_pmos ad=0.36237p pd=2.605u as=0.34p ps=2.68u w=1u l=0.13u
X13 a_23109_61717# a_22851_61717# VGND.t3 VGND.t2 sg13_lv_nmos ad=0.1428p pd=1.52u as=79.8f ps=0.8u w=0.42u l=0.13u
X14 a_24054_61326# freq_divider_0.sg13g2_dfrbp_2_0.RESET_B VDPWR.t1 VDPWR.t0 sg13_lv_pmos ad=79.8f pd=0.8u as=0.36237p ps=2.605u w=0.42u l=0.13u
X15 VGND.t108 ring_0/inverter_ring_0/skullfet_inverter_17.A ring_0/inverter_ring_0/skullfet_inverter_16.A VGND.t107 sg13_lv_nmos ad=4.2687p pd=10.82u as=6.4314p ps=26.72u w=4.05u l=0.4u
X16 VGND.t50 freq_divider_0.sg13g2_dfrbp_2_0.RESET_B a_16801_61717# VGND.t49 sg13_lv_nmos ad=79.8f pd=0.8u as=37.8f ps=0.6u w=0.42u l=0.13u
X17 a_20876_61559# a_19947_61366# a_20747_61559# VGND.t46 sg13_lv_nmos ad=81f pd=0.81u as=0.2163p ps=1.87u w=0.42u l=0.13u
X18 ring_0/inverter_ring_0/skullfet_inverter_12.A ring_0/inverter_ring_0/skullfet_inverter_13.A ring_0/inverter_ring_0/skullfet_inverter_0.VDPWR ring_0/inverter_ring_0/skullfet_inverter_0.VDPWR sg13_lv_pmos ad=6.2694p pd=26.64u as=4.4307p ps=10.9u w=4.05u l=0.4u
X19 VDPWR.t9 a_22511_61578# freq_divider_0.sg13g2_dfrbp_2_2.D VDPWR.t0 sg13_lv_pmos ad=0.2014p pd=1.53u as=0.2128p ps=1.5u w=1.12u l=0.13u
X20 a_23211_61366# a_23350_61250# a_23663_61281# VDPWR.t0 sg13_lv_pmos ad=0.3864p pd=2.93u as=0.43102p ps=2.145u w=1.12u l=0.13u
X21 a_23211_61366# a_23350_61250# a_23668_61632# VGND.t44 sg13_lv_nmos ad=0.2516p pd=2.16u as=0.43315p ps=2.205u w=0.74u l=0.13u
X22 VGND.t7 ring_0/inverter_ring_0/skullfet_inverter_9.A ring_0/inverter_ring_0/skullfet_inverter_8.A VGND.t6 sg13_lv_nmos ad=4.2687p pd=10.82u as=6.4314p ps=26.72u w=4.05u l=0.4u
X23 ring_0/inverter_ring_0/skullfet_inverter_11.A ring_0/inverter_ring_0/skullfet_inverter_12.A ring_0/inverter_ring_0/skullfet_inverter_0.VDPWR ring_0/inverter_ring_0/skullfet_inverter_0.VDPWR sg13_lv_pmos ad=6.2694p pd=26.64u as=4.4307p ps=10.9u w=4.05u l=0.4u
X24 VDPWR.t30 freq_divider_0.sg13g2_dfrbp_2_2.D a_24054_61326# VDPWR.t0 sg13_lv_pmos ad=0.1428p pd=1.52u as=79.8f ps=0.8u w=0.42u l=0.13u
X25 a_22851_61717# a_22511_61578# VDPWR.t9 VDPWR.t0 sg13_lv_pmos ad=79.8f pd=0.8u as=0.2014p ps=1.53u w=0.42u l=0.13u
X26 a_23161_61402# a_22851_61717# a_23039_61402# VDPWR.t0 sg13_lv_pmos ad=52.5f pd=0.67u as=0.25605p ps=1.935u w=0.42u l=0.13u
X27 VDPWR.t26 a_16367_61578# a_16061_61585# VDPWR.t0 sg13_lv_pmos ad=0.2083p pd=1.5u as=0.34p ps=2.68u w=1u l=0.13u
X28 a_17996_61559# a_17067_61366# a_17867_61559# VGND.t77 sg13_lv_nmos ad=81f pd=0.81u as=0.2163p ps=1.87u w=0.42u l=0.13u
X29 freq_divider_0.sg13g2_dfrbp_2_1.D a_19247_61578# VDPWR.t2 VDPWR.t0 sg13_lv_pmos ad=0.2128p pd=1.5u as=0.2083p ps=1.5u w=1.12u l=0.13u
X30 VDPWR.t11 a_21777_61520# freq_divider_0.sg13g2_dfrbp_2_0.RESET_B VDPWR.t0 sg13_lv_pmos ad=0.4657p pd=2.54u as=0.3927p ps=2.99u w=1.155u l=0.13u
X31 a_22945_61717# a_22511_61578# a_22851_61717# VGND.t25 sg13_lv_nmos ad=37.8f pd=0.6u as=0.1428p ps=1.52u w=0.42u l=0.13u
X32 VGND.t70 freq_divider_0.sg13g2_dfrbp_2_0.RESET_B a_24396_61704# VGND.t69 sg13_lv_nmos ad=0.1701p pd=1.65u as=38.85f ps=0.605u w=0.42u l=0.13u
X33 VDPWR.t7 a_22511_61578# a_22205_61585# VDPWR.t0 sg13_lv_pmos ad=0.2083p pd=1.5u as=0.34p ps=2.68u w=1u l=0.13u
X34 ring_0/inverter_ring_0/skullfet_inverter_3.A ring_0/inverter_ring_0/skullfet_inverter_4.A ring_0/inverter_ring_0/skullfet_inverter_0.VDPWR ring_0/inverter_ring_0/skullfet_inverter_0.VDPWR sg13_lv_pmos ad=6.2694p pd=26.64u as=4.4307p ps=10.9u w=4.05u l=0.4u
X35 a_24396_61704# a_23219_61640# a_24011_61559# VGND.t18 sg13_lv_nmos ad=38.85f pd=0.605u as=0.1596p ps=1.6u w=0.42u l=0.13u
X36 a_21856_61617# a_21980_61316# VDPWR.t11 VDPWR.t0 sg13_lv_pmos ad=0.2442p pd=2.06u as=0.4657p ps=2.54u w=0.66u l=0.13u
X37 uo_out[2].t1 a_18941_61585# VGND.t33 VGND.t32 sg13_lv_nmos ad=0.1406p pd=1.12u as=0.2516p ps=2.16u w=0.74u l=0.13u
X38 ring_0/inverter_ring_0/skullfet_inverter_17.A ring_0/inverter_ring_0/skullfet_inverter_18.A ring_0/inverter_ring_0/skullfet_inverter_0.VDPWR ring_0/inverter_ring_0/skullfet_inverter_0.VDPWR sg13_lv_pmos ad=6.2694p pd=26.64u as=4.4307p ps=10.9u w=4.05u l=0.4u
X39 VGND.t118 ring_0/inverter_ring_0/skullfet_inverter_14.A ring_0/inverter_ring_0/skullfet_inverter_13.A VGND.t117 sg13_lv_nmos ad=4.2687p pd=10.82u as=6.4314p ps=26.72u w=4.05u l=0.4u
X40 uo_out[2].t0 a_18941_61585# VDPWR.t13 VDPWR.t0 sg13_lv_pmos ad=0.2156p pd=1.505u as=0.3808p ps=2.92u w=1.12u l=0.13u
X41 VGND.t17 ring_0/inverter_ring_0/skullfet_inverter_2.A ring_0/inverter_ring_0/skullfet_inverter_1.A VGND.t16 sg13_lv_nmos ad=4.2687p pd=10.82u as=6.4314p ps=26.72u w=4.05u l=0.4u
X42 a_19247_61578# a_19947_61366# a_19897_61402# VDPWR.t0 sg13_lv_pmos ad=0.19115p pd=1.565u as=52.5f ps=0.67u w=0.42u l=0.13u
X43 ring_0/inverter_ring_0/skullfet_inverter_4.A ring_0/inverter_ring_0/skullfet_inverter_5.A ring_0/inverter_ring_0/skullfet_inverter_0.VDPWR ring_0/inverter_ring_0/skullfet_inverter_0.VDPWR sg13_lv_pmos ad=6.2694p pd=26.64u as=4.4307p ps=10.9u w=4.05u l=0.4u
X44 VGND.t88 ring_0/inverter_ring_0/skullfet_inverter_11.A ring_0/inverter_ring_0/skullfet_inverter_10.A VGND.t87 sg13_lv_nmos ad=4.2687p pd=10.82u as=6.4314p ps=26.72u w=4.05u l=0.4u
X45 VDPWR.t12 a_18941_61585# uo_out[2].t0 VDPWR.t0 sg13_lv_pmos ad=0.3808p pd=2.92u as=0.2156p ps=1.505u w=1.12u l=0.13u
X46 VGND.t39 ring_0/inverter_ring_0/skullfet_inverter_0.A ring_0/inverter_ring_0/skullfet_inverter_0.Y VGND.t38 sg13_lv_nmos ad=4.2687p pd=10.82u as=6.4314p ps=26.72u w=4.05u l=0.4u
X47 a_20876_61559# a_19947_61366# a_20790_61326# VDPWR.t0 sg13_lv_pmos ad=79.8f pd=0.8u as=0.1428p ps=1.52u w=0.42u l=0.13u
X48 a_18106_61326# a_17206_61250# a_17996_61559# VDPWR.t0 sg13_lv_pmos ad=54.6f pd=0.68u as=79.8f ps=0.8u w=0.42u l=0.13u
X49 VGND.t5 ring_0/inverter_ring_0/skullfet_inverter_3.A ring_0/inverter_ring_0/skullfet_inverter_2.A VGND.t4 sg13_lv_nmos ad=4.2687p pd=10.82u as=6.4314p ps=26.72u w=4.05u l=0.4u
X50 VGND.t116 ring_0/inverter_ring_0/skullfet_inverter_16.A uo_out[0].t0 VGND.t115 sg13_lv_nmos ad=4.2687p pd=10.82u as=6.4314p ps=26.72u w=4.05u l=0.4u
X51 ring_0/inverter_ring_0/skullfet_inverter_18.A ring_0/inverter_ring_0/skullfet_inverter_19.A ring_0/inverter_ring_0/skullfet_inverter_0.VDPWR ring_0/inverter_ring_0/skullfet_inverter_0.VDPWR sg13_lv_pmos ad=6.2694p pd=26.64u as=4.4307p ps=10.9u w=4.05u l=0.4u
X52 a_19947_61366# a_20086_61250# a_20399_61281# VDPWR.t0 sg13_lv_pmos ad=0.3864p pd=2.93u as=0.43102p ps=2.145u w=1.12u l=0.13u
X53 ring_0/inverter_ring_0/skullfet_inverter_9.A ring_0/inverter_ring_0/skullfet_inverter_10.A ring_0/inverter_ring_0/skullfet_inverter_0.VDPWR ring_0/inverter_ring_0/skullfet_inverter_0.VDPWR sg13_lv_pmos ad=6.2694p pd=26.64u as=4.4307p ps=10.9u w=4.05u l=0.4u
X54 VGND.t24 a_22511_61578# freq_divider_0.sg13g2_dfrbp_2_2.D VGND.t23 sg13_lv_nmos ad=0.2516p pd=2.16u as=0.1406p ps=1.12u w=0.74u l=0.13u
X55 VGND.t101 uo_out[0].t2 ring_0/inverter_ring_0/skullfet_inverter_14.A VGND.t100 sg13_lv_nmos ad=4.2687p pd=10.82u as=6.4314p ps=26.72u w=4.05u l=0.4u
X56 VGND.t112 a_22205_61585# uo_out[1].t1 VGND.t111 sg13_lv_nmos ad=0.2516p pd=2.16u as=0.1406p ps=1.12u w=0.74u l=0.13u
X57 a_19681_61717# a_19247_61578# a_19587_61717# VGND.t15 sg13_lv_nmos ad=37.8f pd=0.6u as=0.1428p ps=1.52u w=0.42u l=0.13u
X58 a_17996_61559# a_17067_61366# a_17910_61326# VDPWR.t0 sg13_lv_pmos ad=79.8f pd=0.8u as=0.1428p ps=1.52u w=0.42u l=0.13u
X59 a_19955_61640# a_20086_61250# a_19247_61578# VDPWR.t0 sg13_lv_pmos ad=0.34p pd=2.68u as=0.19115p ps=1.565u w=1u l=0.13u
X60 a_20986_61326# a_20086_61250# a_20876_61559# VDPWR.t0 sg13_lv_pmos ad=54.6f pd=0.68u as=79.8f ps=0.8u w=0.42u l=0.13u
X61 a_16895_61402# freq_divider_0.sg13g2_dfrbp_2_0.RESET_B a_16707_61717# VDPWR.t0 sg13_lv_pmos ad=0.25605p pd=1.935u as=79.8f ps=0.8u w=0.42u l=0.13u
X62 a_24140_61559# a_23211_61366# a_24054_61326# VDPWR.t0 sg13_lv_pmos ad=79.8f pd=0.8u as=0.1428p ps=1.52u w=0.42u l=0.13u
X63 a_17067_61366# a_17206_61250# a_17519_61281# VDPWR.t0 sg13_lv_pmos ad=0.3864p pd=2.93u as=0.43102p ps=2.145u w=1.12u l=0.13u
X64 a_23039_61402# freq_divider_0.sg13g2_dfrbp_2_0.RESET_B a_22851_61717# VDPWR.t0 sg13_lv_pmos ad=0.25605p pd=1.935u as=79.8f ps=0.8u w=0.42u l=0.13u
X65 a_17067_61366# a_17206_61250# a_17524_61632# VGND.t53 sg13_lv_nmos ad=0.2516p pd=2.16u as=0.43315p ps=2.205u w=0.74u l=0.13u
X66 VDPWR.t32 freq_divider_0.sg13g2_dfrbp_2_0.D a_17910_61326# VDPWR.t0 sg13_lv_pmos ad=0.1428p pd=1.52u as=79.8f ps=0.8u w=0.42u l=0.13u
X67 freq_divider_0.sg13g2_dfrbp_2_1.D a_19247_61578# VGND.t11 VGND.t14 sg13_lv_nmos ad=0.1406p pd=1.12u as=0.1331p ps=1.12u w=0.74u l=0.13u
X68 a_21132_61704# a_19955_61640# a_20747_61559# VGND.t78 sg13_lv_nmos ad=38.85f pd=0.605u as=0.1596p ps=1.6u w=0.42u l=0.13u
X69 a_17910_61326# a_17206_61250# a_17996_61559# VGND.t95 sg13_lv_nmos ad=0.1296p pd=1.52u as=81f ps=0.81u w=0.42u l=0.13u
X70 a_19845_61717# a_20086_61250# a_19247_61578# VGND.t103 sg13_lv_nmos ad=0.1428p pd=1.52u as=0.12665p ps=1.145u w=0.42u l=0.13u
X71 a_16965_61717# a_16707_61717# VGND.t50 VGND.t49 sg13_lv_nmos ad=0.1428p pd=1.52u as=79.8f ps=0.8u w=0.42u l=0.13u
X72 a_19897_61402# a_19587_61717# a_19775_61402# VDPWR.t0 sg13_lv_pmos ad=52.5f pd=0.67u as=0.25605p ps=1.935u w=0.42u l=0.13u
X73 a_20790_61326# a_20086_61250# a_20876_61559# VGND.t102 sg13_lv_nmos ad=0.1296p pd=1.52u as=81f ps=0.81u w=0.42u l=0.13u
X74 a_18252_61704# a_17075_61640# a_17867_61559# VGND.t119 sg13_lv_nmos ad=38.85f pd=0.605u as=0.1596p ps=1.6u w=0.42u l=0.13u
X75 VGND.t13 a_19247_61578# freq_divider_0.sg13g2_dfrbp_2_1.D VGND.t12 sg13_lv_nmos ad=0.2516p pd=2.16u as=0.1406p ps=1.12u w=0.74u l=0.13u
X76 VGND.t31 a_18941_61585# uo_out[2].t1 VGND.t30 sg13_lv_nmos ad=0.2516p pd=2.16u as=0.1406p ps=1.12u w=0.74u l=0.13u
X77 a_24140_61559# a_23211_61366# a_24011_61559# VGND.t37 sg13_lv_nmos ad=81f pd=0.81u as=0.2163p ps=1.87u w=0.42u l=0.13u
X78 a_16965_61717# a_17206_61250# a_16367_61578# VGND.t94 sg13_lv_nmos ad=0.1428p pd=1.52u as=0.12665p ps=1.145u w=0.42u l=0.13u
X79 VGND.t11 a_19247_61578# a_18941_61585# VGND.t10 sg13_lv_nmos ad=0.1331p pd=1.12u as=0.2176p ps=1.96u w=0.64u l=0.13u
X80 a_17996_61559# freq_divider_0.sg13g2_dfrbp_2_0.RESET_B VDPWR.t21 VDPWR.t0 sg13_lv_pmos ad=0.147p pd=1.54u as=0.1563p ps=1.22u w=0.42u l=0.13u
X81 VDPWR.t23 a_19955_61640# a_20986_61326# VDPWR.t0 sg13_lv_pmos ad=0.1563p pd=1.22u as=54.6f ps=0.68u w=0.42u l=0.13u
X82 a_20790_61326# freq_divider_0.sg13g2_dfrbp_2_1.D a_21529_61717# VGND.t90 sg13_lv_nmos ad=0.1428p pd=1.52u as=60.89999f ps=0.71u w=0.42u l=0.13u
X83 VDPWR.t18 a_17996_61559# a_17075_61640# VDPWR.t0 sg13_lv_pmos ad=0.36237p pd=2.605u as=0.34p ps=2.68u w=1u l=0.13u
X84 VGND.t48 ring_0/inverter_ring_0/skullfet_inverter_0.Y ring_0/inverter_ring_0/skullfet_inverter_19.A VGND.t47 sg13_lv_nmos ad=4.2687p pd=10.82u as=6.4314p ps=26.72u w=4.05u l=0.4u
X85 a_24140_61559# freq_divider_0.sg13g2_dfrbp_2_0.RESET_B VDPWR.t6 VDPWR.t0 sg13_lv_pmos ad=0.147p pd=1.54u as=0.1563p ps=1.22u w=0.42u l=0.13u
X86 ring_0/inverter_ring_0/skullfet_inverter_5.A ring_0/inverter_ring_0/skullfet_inverter_6.A ring_0/inverter_ring_0/skullfet_inverter_0.VDPWR ring_0/inverter_ring_0/skullfet_inverter_0.VDPWR sg13_lv_pmos ad=6.2694p pd=26.64u as=4.4307p ps=10.9u w=4.05u l=0.4u
X87 VDPWR.t3 a_19247_61578# freq_divider_0.sg13g2_dfrbp_2_1.D VDPWR.t0 sg13_lv_pmos ad=0.2014p pd=1.53u as=0.2128p ps=1.5u w=1.12u l=0.13u
X88 VGND.t20 ring_0/inverter_ring_0/skullfet_inverter_8.A ring_0/inverter_ring_0/skullfet_inverter_7.A VGND.t19 sg13_lv_nmos ad=4.2687p pd=10.82u as=6.4314p ps=26.72u w=4.05u l=0.4u
X89 a_20399_61281# uo_out[1].t2 a_20086_61250# VDPWR.t0 sg13_lv_pmos ad=0.43102p pd=2.145u as=0.3808p ps=2.92u w=1.12u l=0.13u
X90 VDPWR.t1 a_24140_61559# a_23219_61640# VDPWR.t0 sg13_lv_pmos ad=0.36237p pd=2.605u as=0.34p ps=2.68u w=1u l=0.13u
X91 a_23219_61640# a_23350_61250# a_22511_61578# VDPWR.t0 sg13_lv_pmos ad=0.34p pd=2.68u as=0.19115p ps=1.565u w=1u l=0.13u
X92 VDPWR.t21 a_17075_61640# a_18106_61326# VDPWR.t0 sg13_lv_pmos ad=0.1563p pd=1.22u as=54.6f ps=0.68u w=0.42u l=0.13u
X93 a_19587_61717# a_19247_61578# VDPWR.t3 VDPWR.t0 sg13_lv_pmos ad=79.8f pd=0.8u as=0.2014p ps=1.53u w=0.42u l=0.13u
X94 VGND.t9 ring_0/inverter_ring_0/skullfet_inverter_1.A ring_0/inverter_ring_0/skullfet_inverter_0.A VGND.t8 sg13_lv_nmos ad=4.2687p pd=10.82u as=6.4314p ps=26.72u w=4.05u l=0.4u
X95 ring_0/inverter_ring_0/skullfet_inverter_10.A ring_0/inverter_ring_0/skullfet_inverter_11.A ring_0/inverter_ring_0/skullfet_inverter_0.VDPWR ring_0/inverter_ring_0/skullfet_inverter_0.VDPWR sg13_lv_pmos ad=6.2694p pd=26.64u as=4.4307p ps=10.9u w=4.05u l=0.4u
X96 VDPWR.t34 a_22205_61585# uo_out[1].t0 VDPWR.t0 sg13_lv_pmos ad=0.3808p pd=2.92u as=0.2156p ps=1.505u w=1.12u l=0.13u
X97 a_17519_61281# uo_out[2].t2 a_17206_61250# VDPWR.t0 sg13_lv_pmos ad=0.43102p pd=2.145u as=0.3808p ps=2.92u w=1.12u l=0.13u
X98 VGND.t52 ring_0/inverter_ring_0/skullfet_inverter_12.A ring_0/inverter_ring_0/skullfet_inverter_11.A VGND.t51 sg13_lv_nmos ad=4.2687p pd=10.82u as=6.4314p ps=26.72u w=4.05u l=0.4u
X99 a_23109_61717# a_23350_61250# a_22511_61578# VGND.t43 sg13_lv_nmos ad=0.1428p pd=1.52u as=0.12665p ps=1.145u w=0.42u l=0.13u
X100 ring_0/inverter_ring_0/skullfet_inverter_0.A ring_0/inverter_ring_0/skullfet_inverter_1.A ring_0/inverter_ring_0/skullfet_inverter_0.VDPWR ring_0/inverter_ring_0/skullfet_inverter_0.VDPWR sg13_lv_pmos ad=6.2694p pd=26.64u as=4.4307p ps=10.9u w=4.05u l=0.4u
X101 ring_0/inverter_ring_0/skullfet_inverter_16.A ring_0/inverter_ring_0/skullfet_inverter_17.A ring_0/inverter_ring_0/skullfet_inverter_0.VDPWR ring_0/inverter_ring_0/skullfet_inverter_0.VDPWR sg13_lv_pmos ad=6.2694p pd=26.64u as=4.4307p ps=10.9u w=4.05u l=0.4u
X102 a_21980_61316# a_21980_61316# VGND.t28 VGND.t27 sg13_lv_nmos ad=0.111p pd=1.34u as=0.20432p ps=1.585u w=0.3u l=0.13u
X103 VGND.t68 freq_divider_0.sg13g2_dfrbp_2_0.RESET_B a_19681_61717# VGND.t67 sg13_lv_nmos ad=79.8f pd=0.8u as=37.8f ps=0.6u w=0.42u l=0.13u
X104 ring_0/inverter_ring_0/skullfet_inverter_2.A ring_0/inverter_ring_0/skullfet_inverter_3.A ring_0/inverter_ring_0/skullfet_inverter_0.VDPWR ring_0/inverter_ring_0/skullfet_inverter_0.VDPWR sg13_lv_pmos ad=6.2694p pd=26.64u as=4.4307p ps=10.9u w=4.05u l=0.4u
X105 uo_out[0].t1 ring_0/inverter_ring_0/skullfet_inverter_16.A ring_0/inverter_ring_0/skullfet_inverter_0.VDPWR ring_0/inverter_ring_0/skullfet_inverter_0.VDPWR sg13_lv_pmos ad=6.2694p pd=26.64u as=4.4307p ps=10.9u w=4.05u l=0.4u
X106 a_21529_61717# freq_divider_0.sg13g2_dfrbp_2_0.RESET_B VGND.t35 VGND.t66 sg13_lv_nmos ad=60.89999f pd=0.71u as=0.1626p ps=1.415u w=0.42u l=0.13u
X107 VGND.t35 a_20876_61559# a_19955_61640# VGND.t34 sg13_lv_nmos ad=0.1626p pd=1.415u as=0.2516p ps=2.16u w=0.74u l=0.13u
X108 uo_out[3].t1 a_16061_61585# VGND.t57 VGND.t56 sg13_lv_nmos ad=0.1406p pd=1.12u as=0.2516p ps=2.16u w=0.74u l=0.13u
X109 a_20404_61632# uo_out[1].t2 a_20086_61250# VGND.t29 sg13_lv_nmos ad=0.43315p pd=2.205u as=0.2516p ps=2.16u w=0.74u l=0.13u
X110 VGND.t28 a_21856_61617# a_21777_61520# VGND.t60 sg13_lv_nmos ad=0.20432p pd=1.585u as=0.27427p ps=2.28u w=0.795u l=0.13u
X111 a_16367_61578# a_17067_61366# a_17017_61402# VDPWR.t0 sg13_lv_pmos ad=0.19115p pd=1.565u as=52.5f ps=0.67u w=0.42u l=0.13u
X112 ring_0/inverter_ring_0/skullfet_inverter_14.A uo_out[0].t2 ring_0/inverter_ring_0/skullfet_inverter_0.VDPWR ring_0/inverter_ring_0/skullfet_inverter_0.VDPWR sg13_lv_pmos ad=6.2694p pd=26.64u as=4.4307p ps=10.9u w=4.05u l=0.4u
X113 VGND.t80 ring_0/inverter_ring_0/skullfet_inverter_4.A ring_0/inverter_ring_0/skullfet_inverter_3.A VGND.t79 sg13_lv_nmos ad=4.2687p pd=10.82u as=6.4314p ps=26.72u w=4.05u l=0.4u
X114 VDPWR.t6 a_23219_61640# a_24250_61326# VDPWR.t0 sg13_lv_pmos ad=0.1563p pd=1.22u as=54.6f ps=0.68u w=0.42u l=0.13u
X115 a_24250_61326# a_23350_61250# a_24140_61559# VDPWR.t0 sg13_lv_pmos ad=54.6f pd=0.68u as=79.8f ps=0.8u w=0.42u l=0.13u
X116 a_20790_61326# freq_divider_0.sg13g2_dfrbp_2_0.RESET_B VDPWR.t15 VDPWR.t0 sg13_lv_pmos ad=79.8f pd=0.8u as=0.36237p ps=2.605u w=0.42u l=0.13u
X117 a_24054_61326# freq_divider_0.sg13g2_dfrbp_2_2.D a_24793_61717# VGND.t89 sg13_lv_nmos ad=0.1428p pd=1.52u as=60.89999f ps=0.71u w=0.42u l=0.13u
X118 a_22511_61578# a_23211_61366# a_23219_61640# VGND.t36 sg13_lv_nmos ad=0.12665p pd=1.145u as=0.3473p ps=2.71u w=0.74u l=0.13u
X119 a_18649_61717# freq_divider_0.sg13g2_dfrbp_2_0.RESET_B VGND.t59 VGND.t65 sg13_lv_nmos ad=60.89999f pd=0.71u as=0.1626p ps=1.415u w=0.42u l=0.13u
X120 freq_divider_0.sg13g2_dfrbp_2_0.D a_16367_61578# VDPWR.t26 VDPWR.t0 sg13_lv_pmos ad=0.2128p pd=1.5u as=0.2083p ps=1.5u w=1.12u l=0.13u
X121 a_17524_61632# uo_out[2].t2 a_17206_61250# VGND.t53 sg13_lv_nmos ad=0.43315p pd=2.205u as=0.2516p ps=2.16u w=0.74u l=0.13u
X122 VDPWR.t2 a_19247_61578# a_18941_61585# VDPWR.t0 sg13_lv_pmos ad=0.2083p pd=1.5u as=0.34p ps=2.68u w=1u l=0.13u
X123 VGND.t97 ring_0/inverter_ring_0/skullfet_inverter_7.A ring_0/inverter_ring_0/skullfet_inverter_6.A VGND.t96 sg13_lv_nmos ad=4.2687p pd=10.82u as=6.4314p ps=26.72u w=4.05u l=0.4u
X124 a_24793_61717# freq_divider_0.sg13g2_dfrbp_2_0.RESET_B VGND.t1 VGND.t64 sg13_lv_nmos ad=60.89999f pd=0.71u as=0.1626p ps=1.415u w=0.42u l=0.13u
X125 a_17075_61640# a_17206_61250# a_16367_61578# VDPWR.t0 sg13_lv_pmos ad=0.34p pd=2.68u as=0.19115p ps=1.565u w=1u l=0.13u
X126 uo_out[3].t0 a_16061_61585# VDPWR.t17 VDPWR.t0 sg13_lv_pmos ad=0.2156p pd=1.505u as=0.3808p ps=2.92u w=1.12u l=0.13u
X127 a_24054_61326# a_23350_61250# a_24140_61559# VGND.t42 sg13_lv_nmos ad=0.1296p pd=1.52u as=81f ps=0.81u w=0.42u l=0.13u
X128 VDPWR.t16 a_16061_61585# uo_out[3].t0 VDPWR.t0 sg13_lv_pmos ad=0.3808p pd=2.92u as=0.2156p ps=1.505u w=1.12u l=0.13u
X129 a_22511_61578# a_23211_61366# a_23161_61402# VDPWR.t0 sg13_lv_pmos ad=0.19115p pd=1.565u as=52.5f ps=0.67u w=0.42u l=0.13u
X130 ring_0/inverter_ring_0/skullfet_inverter_8.A ring_0/inverter_ring_0/skullfet_inverter_9.A ring_0/inverter_ring_0/skullfet_inverter_0.VDPWR ring_0/inverter_ring_0/skullfet_inverter_0.VDPWR sg13_lv_pmos ad=6.2694p pd=26.64u as=4.4307p ps=10.9u w=4.05u l=0.4u
X131 uo_out[1].t0 a_22205_61585# VDPWR.t33 VDPWR.t0 sg13_lv_pmos ad=0.2156p pd=1.505u as=0.3808p ps=2.92u w=1.12u l=0.13u
X132 ring_0/inverter_ring_0/skullfet_inverter_7.A ring_0/inverter_ring_0/skullfet_inverter_8.A ring_0/inverter_ring_0/skullfet_inverter_0.VDPWR ring_0/inverter_ring_0/skullfet_inverter_0.VDPWR sg13_lv_pmos ad=6.2694p pd=26.64u as=4.4307p ps=10.9u w=4.05u l=0.4u
X133 VGND.t93 ring_0/inverter_ring_0/skullfet_inverter_10.A ring_0/inverter_ring_0/skullfet_inverter_9.A VGND.t92 sg13_lv_nmos ad=4.2687p pd=10.82u as=6.4314p ps=26.72u w=4.05u l=0.4u
X134 VGND.t1 a_24140_61559# a_23219_61640# VGND.t0 sg13_lv_nmos ad=0.1626p pd=1.415u as=0.2516p ps=2.16u w=0.74u l=0.13u
X135 a_23668_61632# uo_out[0].t3 a_23350_61250# VGND.t44 sg13_lv_nmos ad=0.43315p pd=2.205u as=0.2516p ps=2.16u w=0.74u l=0.13u
X136 freq_divider_0.sg13g2_dfrbp_2_2.D a_22511_61578# VDPWR.t7 VDPWR.t0 sg13_lv_pmos ad=0.2128p pd=1.5u as=0.2083p ps=1.5u w=1.12u l=0.13u
X137 a_16801_61717# a_16367_61578# a_16707_61717# VGND.t86 sg13_lv_nmos ad=37.8f pd=0.6u as=0.1428p ps=1.52u w=0.42u l=0.13u
X138 a_19247_61578# a_19947_61366# a_19955_61640# VGND.t45 sg13_lv_nmos ad=0.12665p pd=1.145u as=0.3473p ps=2.71u w=0.74u l=0.13u
X139 ring_0/inverter_ring_0/skullfet_inverter_1.A ring_0/inverter_ring_0/skullfet_inverter_2.A ring_0/inverter_ring_0/skullfet_inverter_0.VDPWR ring_0/inverter_ring_0/skullfet_inverter_0.VDPWR sg13_lv_pmos ad=6.2694p pd=26.64u as=4.4307p ps=10.9u w=4.05u l=0.4u
X140 ring_0/inverter_ring_0/skullfet_inverter_13.A ring_0/inverter_ring_0/skullfet_inverter_14.A ring_0/inverter_ring_0/skullfet_inverter_0.VDPWR ring_0/inverter_ring_0/skullfet_inverter_0.VDPWR sg13_lv_pmos ad=6.2694p pd=26.64u as=4.4307p ps=10.9u w=4.05u l=0.4u
X141 a_19775_61402# freq_divider_0.sg13g2_dfrbp_2_0.RESET_B a_19587_61717# VDPWR.t0 sg13_lv_pmos ad=0.25605p pd=1.935u as=79.8f ps=0.8u w=0.42u l=0.13u
X142 ring_0/inverter_ring_0/skullfet_inverter_0.Y ring_0/inverter_ring_0/skullfet_inverter_0.A ring_0/inverter_ring_0/skullfet_inverter_0.VDPWR ring_0/inverter_ring_0/skullfet_inverter_0.VDPWR sg13_lv_pmos ad=6.2694p pd=26.64u as=4.4307p ps=10.9u w=4.05u l=0.4u
X143 freq_divider_0.sg13g2_dfrbp_2_0.D a_16367_61578# VGND.t82 VGND.t85 sg13_lv_nmos ad=0.1406p pd=1.12u as=0.1331p ps=1.12u w=0.74u l=0.13u
X144 a_17910_61326# freq_divider_0.sg13g2_dfrbp_2_0.D a_18649_61717# VGND.t104 sg13_lv_nmos ad=0.1428p pd=1.52u as=60.89999f ps=0.71u w=0.42u l=0.13u
X145 a_16367_61578# a_17067_61366# a_17075_61640# VGND.t76 sg13_lv_nmos ad=0.12665p pd=1.145u as=0.3473p ps=2.71u w=0.74u l=0.13u
X146 VGND.t3 freq_divider_0.sg13g2_dfrbp_2_0.RESET_B a_22945_61717# VGND.t2 sg13_lv_nmos ad=79.8f pd=0.8u as=37.8f ps=0.6u w=0.42u l=0.13u
X147 a_17017_61402# a_16707_61717# a_16895_61402# VDPWR.t0 sg13_lv_pmos ad=52.5f pd=0.67u as=0.25605p ps=1.935u w=0.42u l=0.13u
X148 VGND.t41 ring_0/inverter_ring_0/skullfet_inverter_18.A ring_0/inverter_ring_0/skullfet_inverter_17.A VGND.t40 sg13_lv_nmos ad=4.2687p pd=10.82u as=6.4314p ps=26.72u w=4.05u l=0.4u
X149 VGND.t84 a_16367_61578# freq_divider_0.sg13g2_dfrbp_2_0.D VGND.t83 sg13_lv_nmos ad=0.2516p pd=2.16u as=0.1406p ps=1.12u w=0.74u l=0.13u
X150 VGND.t106 ring_0/inverter_ring_0/skullfet_inverter_6.A ring_0/inverter_ring_0/skullfet_inverter_5.A VGND.t105 sg13_lv_nmos ad=4.2687p pd=10.82u as=6.4314p ps=26.72u w=4.05u l=0.4u
X151 VGND.t55 a_16061_61585# uo_out[3].t1 VGND.t54 sg13_lv_nmos ad=0.2516p pd=2.16u as=0.1406p ps=1.12u w=0.74u l=0.13u
X152 a_19845_61717# a_19587_61717# VGND.t68 VGND.t67 sg13_lv_nmos ad=0.1428p pd=1.52u as=79.8f ps=0.8u w=0.42u l=0.13u
X153 VGND.t62 ring_0/inverter_ring_0/skullfet_inverter_5.A ring_0/inverter_ring_0/skullfet_inverter_4.A VGND.t61 sg13_lv_nmos ad=4.2687p pd=10.82u as=6.4314p ps=26.72u w=4.05u l=0.4u
X154 VGND.t82 a_16367_61578# a_16061_61585# VGND.t81 sg13_lv_nmos ad=0.1331p pd=1.12u as=0.2176p ps=1.96u w=0.64u l=0.13u
X155 a_23663_61281# uo_out[0].t3 a_23350_61250# VDPWR.t0 sg13_lv_pmos ad=0.43102p pd=2.145u as=0.3808p ps=2.92u w=1.12u l=0.13u
X156 a_19947_61366# a_20086_61250# a_20404_61632# VGND.t29 sg13_lv_nmos ad=0.2516p pd=2.16u as=0.43315p ps=2.205u w=0.74u l=0.13u
X157 VGND.t110 ring_0/inverter_ring_0/skullfet_inverter_19.A ring_0/inverter_ring_0/skullfet_inverter_18.A VGND.t109 sg13_lv_nmos ad=4.2687p pd=10.82u as=6.4314p ps=26.72u w=4.05u l=0.4u
X158 VDPWR.t31 freq_divider_0.sg13g2_dfrbp_2_1.D a_20790_61326# VDPWR.t0 sg13_lv_pmos ad=0.1428p pd=1.52u as=79.8f ps=0.8u w=0.42u l=0.13u
X159 freq_divider_0.sg13g2_dfrbp_2_2.D a_22511_61578# VGND.t22 VGND.t21 sg13_lv_nmos ad=0.1406p pd=1.12u as=0.1331p ps=1.12u w=0.74u l=0.13u
R0 VGND.n199 VGND.n59 36337.9
R1 VGND.n207 VGND.n111 26006.8
R2 VGND.n347 VGND.n111 20289.4
R3 VGND.t79 VGND.n157 19416.2
R4 VGND.n442 VGND.n441 17662.9
R5 VGND.n191 VGND.n70 15262.5
R6 VGND.n199 VGND.n111 12285.4
R7 VGND.n61 VGND.n59 12285.4
R8 VGND.n441 VGND.n440 12279.6
R9 VGND.n197 VGND.t105 12039.2
R10 VGND.t96 VGND.n63 10402.1
R11 VGND.n282 VGND.n275 10052.7
R12 VGND.n443 VGND.n442 9967.62
R13 VGND.n156 VGND.n155 9840.79
R14 VGND.n198 VGND.n61 9066.9
R15 VGND.n266 VGND.n197 7844.55
R16 VGND.n207 VGND.n201 7498.6
R17 VGND.n196 VGND.n195 7474.99
R18 VGND.n155 VGND.n152 7291.79
R19 VGND.n191 VGND.t61 7169.54
R20 VGND.n446 VGND.n65 6899.39
R21 VGND.n450 VGND.n60 6851.13
R22 VGND.n69 VGND.n65 6429.23
R23 VGND.n266 VGND.t4 6051.63
R24 VGND.n200 VGND.n199 6014.02
R25 VGND.n440 VGND.n439 5872.62
R26 VGND.n201 VGND.n200 5699.78
R27 VGND.n440 VGND.n69 5321.16
R28 VGND.n192 VGND.n191 5298.87
R29 VGND.n452 VGND.n451 4953.11
R30 VGND.n442 VGND.n69 4950.06
R31 VGND.n265 VGND.n264 4945.91
R32 VGND.n292 VGND.n152 3511.45
R33 VGND.n155 VGND.n154 3475.34
R34 VGND.n277 VGND.n272 3284.18
R35 VGND.n440 VGND.n71 3154.9
R36 VGND.n197 VGND.n196 3153.12
R37 VGND.n283 VGND.n282 2376.2
R38 VGND.n266 VGND.n154 2220.92
R39 VGND.n444 VGND.n443 2084.31
R40 VGND.n448 VGND.n63 1946.24
R41 VGND.n200 VGND.n198 1880.71
R42 VGND.n157 VGND.n70 1835.32
R43 VGND.n74 VGND.n71 1763.01
R44 VGND.n266 VGND.n198 1734.38
R45 VGND.n197 VGND.n63 1470.05
R46 VGND.n284 VGND.t38 1368.89
R47 VGND.t109 VGND.n277 1347.06
R48 VGND.n277 VGND.t47 1194.61
R49 VGND.t61 VGND.n190 1123.79
R50 VGND.n441 VGND.n70 1061.65
R51 VGND.n284 VGND.n272 977.779
R52 VGND.n60 VGND.t98 964.287
R53 VGND.n266 VGND.n156 905.553
R54 VGND.t98 VGND.n59 876.317
R55 VGND.n450 VGND.n61 837.723
R56 VGND.n276 VGND.n152 814.62
R57 VGND.n236 VGND.n233 744.615
R58 VGND.n461 VGND.n5 744.615
R59 VGND.n53 VGND.n52 744.615
R60 VGND.n206 VGND.t100 675.663
R61 VGND.n195 VGND.t4 656.004
R62 VGND.n439 VGND.t105 656.004
R63 VGND.n196 VGND.t79 615.229
R64 VGND.n156 VGND.n151 608.424
R65 VGND.n348 VGND.n59 575.212
R66 VGND.n196 VGND.n192 498.868
R67 VGND.n236 VGND.t2 480
R68 VGND.n461 VGND.t67 480
R69 VGND.n52 VGND.t49 480
R70 VGND.n445 VGND.t6 455.887
R71 VGND.n74 VGND.t96 427.755
R72 VGND.n266 VGND.n265 402.269
R73 VGND.n451 VGND.n450 395.865
R74 VGND.n266 VGND.n201 392.892
R75 VGND.t117 VGND.n347 372.399
R76 VGND.n283 VGND.n272 344.149
R77 VGND.t47 VGND.n275 335.173
R78 VGND.n68 VGND.t6 330.428
R79 VGND.n292 VGND.t107 318.406
R80 VGND.n347 VGND.n346 307.757
R81 VGND.n157 VGND.n154 278.079
R82 VGND.n232 VGND.t23 260.005
R83 VGND.n16 VGND.t12 260.005
R84 VGND.t83 VGND.n54 260.005
R85 VGND.t21 VGND.n230 234.738
R86 VGND.t14 VGND.n14 234.738
R87 VGND.n56 VGND.t85 234.738
R88 VGND.n243 VGND.t26 232.869
R89 VGND.n25 VGND.t10 232.869
R90 VGND.t81 VGND.n43 232.869
R91 VGND.t16 VGND.n151 231.615
R92 VGND.t60 VGND.n225 228.233
R93 VGND.n276 VGND.t8 227.947
R94 VGND.n198 VGND.n63 226.054
R95 VGND.n250 VGND.t34 200.339
R96 VGND.n31 VGND.t58 200.339
R97 VGND.n212 VGND.t0 200.339
R98 VGND.n248 VGND.t90 195.942
R99 VGND.n12 VGND.t104 194.969
R100 VGND.n449 VGND.n448 194.851
R101 VGND.n247 VGND.t111 185.124
R102 VGND.n29 VGND.t30 185.124
R103 VGND.t54 VGND.n41 185.124
R104 VGND.t113 VGND.n228 184.825
R105 VGND.t32 VGND.n12 184.825
R106 VGND.n264 VGND.t89 180.052
R107 VGND.n228 VGND.t27 172.145
R108 VGND.n452 VGND.t56 169.907
R109 VGND.n282 VGND.t40 164.255
R110 VGND.t78 VGND.t74 159.763
R111 VGND.t119 VGND.t72 159.763
R112 VGND.t18 VGND.t69 159.763
R113 VGND.t46 VGND.n221 156.929
R114 VGND.t77 VGND.n9 156.929
R115 VGND.t37 VGND.n209 156.929
R116 VGND.n254 VGND.t102 154.614
R117 VGND.n35 VGND.t95 154.614
R118 VGND.n215 VGND.t42 154.614
R119 VGND.n71 VGND.n65 151.276
R120 VGND.t66 VGND.n223 149.62
R121 VGND.t65 VGND.n11 149.62
R122 VGND.t64 VGND.n211 149.62
R123 VGND.t2 VGND.t36 138.463
R124 VGND.t67 VGND.t45 138.463
R125 VGND.t49 VGND.t76 138.463
R126 VGND.n265 VGND.t115 132.323
R127 VGND.n448 VGND.t19 128.216
R128 VGND.n451 VGND.n59 122.921
R129 VGND.t38 VGND.n283 113.026
R130 VGND.n233 VGND.t25 110.237
R131 VGND.t15 VGND.n5 110.237
R132 VGND.t86 VGND.n53 110.237
R133 VGND.n221 VGND.n5 106.212
R134 VGND.n53 VGND.n9 106.212
R135 VGND.n233 VGND.n209 106.212
R136 VGND.t102 VGND.n253 100.478
R137 VGND.t95 VGND.n34 100.478
R138 VGND.t42 VGND.n214 100.478
R139 VGND.n254 VGND.t46 99.7516
R140 VGND.n35 VGND.t77 99.7516
R141 VGND.n215 VGND.t37 99.7516
R142 VGND.n443 VGND.n68 95.8456
R143 VGND.t19 VGND.n447 95.5275
R144 VGND.n250 VGND.t66 93.8297
R145 VGND.n31 VGND.t65 93.8297
R146 VGND.n212 VGND.t64 93.8297
R147 VGND.t27 VGND.n225 86.222
R148 VGND.n292 VGND.n151 84.6642
R149 VGND.n447 VGND.n446 83.8532
R150 VGND.n253 VGND.t78 75.5501
R151 VGND.n34 VGND.t119 75.5501
R152 VGND.n214 VGND.t18 75.5501
R153 VGND.t44 VGND.t43 73.8467
R154 VGND.t29 VGND.t103 73.8467
R155 VGND.t53 VGND.t94 73.8467
R156 VGND.n247 VGND.t113 73.5423
R157 VGND.n29 VGND.t32 73.5423
R158 VGND.t56 VGND.n41 73.5423
R159 VGND.t111 VGND.n243 73.244
R160 VGND.t30 VGND.n25 73.244
R161 VGND.n43 VGND.t54 73.244
R162 VGND.n291 VGND.t8 72.396
R163 VGND.n346 VGND.t100 65.0575
R164 VGND.n348 VGND.t117 63.8663
R165 VGND.n450 VGND.t51 63.5677
R166 VGND.t90 VGND.n223 63.3986
R167 VGND.t104 VGND.n11 63.3986
R168 VGND.n211 VGND.t89 63.3986
R169 VGND.t0 VGND.n210 59.0031
R170 VGND.t34 VGND.n222 59.0031
R171 VGND.t58 VGND.n10 59.0031
R172 VGND.n448 VGND.t87 55.0827
R173 VGND.n267 VGND.t16 51.425
R174 VGND.n203 VGND.t107 51.1311
R175 VGND.t25 VGND.n232 48.4827
R176 VGND.n16 VGND.t15 48.4827
R177 VGND.n54 VGND.t86 48.4827
R178 VGND.t51 VGND.n449 47.9255
R179 VGND.n445 VGND.t92 47.7166
R180 VGND.n445 VGND.n66 44.7738
R181 VGND.n293 VGND.t40 44.7032
R182 VGND.t115 VGND.n207 42.4247
R183 VGND.n66 VGND.t87 41.6077
R184 VGND.n281 VGND.t109 38.7252
R185 VGND.t74 VGND.n222 38.7147
R186 VGND.t72 VGND.n10 38.7147
R187 VGND.t69 VGND.n210 38.7147
R188 VGND.n282 VGND.n276 36.6123
R189 VGND.t92 VGND.n444 36.1063
R190 VGND.n248 VGND.t60 31.1079
R191 VGND.t26 VGND.n230 28.3754
R192 VGND.t10 VGND.n14 28.3754
R193 VGND.n56 VGND.t81 28.3754
R194 VGND.n231 VGND.t21 27.8464
R195 VGND.n15 VGND.t14 27.8464
R196 VGND.t85 VGND.n55 27.8464
R197 VGND.t36 VGND.t44 24.6159
R198 VGND.t45 VGND.t29 24.6159
R199 VGND.t76 VGND.t53 24.6159
R200 VGND.n292 VGND.n291 22.6588
R201 VGND.n207 VGND.n206 22.6333
R202 VGND.n446 VGND.n445 18.8055
R203 VGND.n290 VGND.n289 18.1658
R204 VGND.n269 VGND.n268 18.1658
R205 VGND.n395 VGND.n394 18.1658
R206 VGND.n77 VGND.n64 18.1658
R207 VGND.n76 VGND.n75 18.1658
R208 VGND.n438 VGND.n437 18.1658
R209 VGND.n190 VGND.n189 18.1658
R210 VGND.n159 VGND.n158 18.1658
R211 VGND.n422 VGND.n421 18.1658
R212 VGND.n87 VGND.n67 18.1658
R213 VGND.n88 VGND.n62 18.1658
R214 VGND.n205 VGND.n204 18.1658
R215 VGND.n202 VGND.n140 18.1658
R216 VGND.n295 VGND.n294 18.1658
R217 VGND.n280 VGND.n279 18.1658
R218 VGND.n274 VGND.n273 18.1658
R219 VGND.n345 VGND.n344 18.1658
R220 VGND.n350 VGND.n349 18.1658
R221 VGND.n376 VGND.n375 18.1658
R222 VGND.n194 VGND.n193 18.1658
R223 VGND.n286 VGND.n285 18.1658
R224 VGND.n257 VGND.n254 18.0261
R225 VGND.n459 VGND.n35 18.0261
R226 VGND.n263 VGND.n215 18.0261
R227 VGND.t23 VGND.n231 17.5282
R228 VGND.t12 VGND.n15 17.5282
R229 VGND.n55 VGND.t83 17.5282
R230 VGND.n213 VGND.t1 17.2928
R231 VGND.n36 VGND.t73 17.2395
R232 VGND.n255 VGND.t75 17.2395
R233 VGND.n216 VGND.t70 17.2395
R234 VGND.n47 VGND.t84 17.2297
R235 VGND.n21 VGND.t13 17.2297
R236 VGND.n239 VGND.t24 17.2297
R237 VGND.n40 VGND.t50 17.2268
R238 VGND.n32 VGND.t59 17.2268
R239 VGND.n19 VGND.t68 17.2268
R240 VGND.n251 VGND.t35 17.2268
R241 VGND.n220 VGND.t3 17.2268
R242 VGND.n402 VGND.t82 17.212
R243 VGND.n23 VGND.t11 17.212
R244 VGND.n241 VGND.t22 17.212
R245 VGND.n57 VGND.t57 17.2025
R246 VGND.n27 VGND.t33 17.2025
R247 VGND.n245 VGND.t114 17.2025
R248 VGND.n226 VGND.t28 17.174
R249 VGND.n290 VGND.t9 17.0362
R250 VGND.n268 VGND.t17 17.0362
R251 VGND.n394 VGND.t88 17.0362
R252 VGND.n64 VGND.t20 17.0362
R253 VGND.n75 VGND.t97 17.0362
R254 VGND.n438 VGND.t106 17.0362
R255 VGND.n190 VGND.t62 17.0362
R256 VGND.n158 VGND.t80 17.0362
R257 VGND.n421 VGND.t7 17.0362
R258 VGND.n67 VGND.t93 17.0362
R259 VGND.n62 VGND.t52 17.0362
R260 VGND.n205 VGND.t116 17.0362
R261 VGND.n202 VGND.t108 17.0362
R262 VGND.n294 VGND.t41 17.0362
R263 VGND.n280 VGND.t110 17.0362
R264 VGND.n274 VGND.t48 17.0362
R265 VGND.n345 VGND.t101 17.0362
R266 VGND.n349 VGND.t118 17.0362
R267 VGND.n375 VGND.t99 17.0362
R268 VGND.n194 VGND.t5 17.0362
R269 VGND.n285 VGND.t39 17.0362
R270 VGND.n264 VGND.n263 17.0005
R271 VGND.n263 VGND.n211 17.0005
R272 VGND.n263 VGND.n212 17.0005
R273 VGND.n258 VGND.n257 17.0005
R274 VGND.n257 VGND.n230 17.0005
R275 VGND.n257 VGND.n247 17.0005
R276 VGND.n257 VGND.n229 17.0005
R277 VGND.n257 VGND.n225 17.0005
R278 VGND.n257 VGND.n223 17.0005
R279 VGND.n257 VGND.n250 17.0005
R280 VGND.n463 VGND.n1 17.0005
R281 VGND.n464 VGND.n463 17.0005
R282 VGND.n459 VGND.n18 17.0005
R283 VGND.n459 VGND.n14 17.0005
R284 VGND.n459 VGND.n29 17.0005
R285 VGND.n459 VGND.n13 17.0005
R286 VGND.n459 VGND.n11 17.0005
R287 VGND.n459 VGND.n31 17.0005
R288 VGND.n454 VGND.n453 17.0005
R289 VGND.n453 VGND.n56 17.0005
R290 VGND.n453 VGND.n41 17.0005
R291 VGND.n453 VGND.n58 17.0005
R292 VGND.n453 VGND.n452 17.0005
R293 VGND.n285 VGND.n284 16.9935
R294 VGND.n267 VGND.n266 16.2915
R295 VGND.n266 VGND.n203 16.2014
R296 VGND.n444 VGND.n67 15.6652
R297 VGND.n281 VGND.n280 15.5838
R298 VGND.n394 VGND.n66 15.4962
R299 VGND.n294 VGND.n293 15.4044
R300 VGND.n449 VGND.n62 15.3111
R301 VGND.n203 VGND.n202 15.2207
R302 VGND.n268 VGND.n267 15.2126
R303 VGND.n349 VGND.n348 14.8829
R304 VGND.n206 VGND.n205 14.853
R305 VGND.n346 VGND.n345 14.853
R306 VGND.n291 VGND.n290 14.6742
R307 VGND.n293 VGND.n292 14.2225
R308 VGND.n447 VGND.n64 14.1685
R309 VGND.n282 VGND.n281 12.3693
R310 VGND.n421 VGND.n68 11.5621
R311 VGND.n275 VGND.n274 11.5336
R312 VGND.n75 VGND.n74 11.0666
R313 VGND.n439 VGND.n438 10.3577
R314 VGND.n195 VGND.n194 10.3577
R315 VGND.n375 VGND.n60 9.85117
R316 VGND.n192 VGND.n158 9.69267
R317 VGND.n466 VGND.n465 9.3481
R318 VGND.n404 VGND.n403 9.34032
R319 VGND.n44 VGND.t55 8.74885
R320 VGND.n26 VGND.t31 8.74885
R321 VGND.n244 VGND.t112 8.74885
R322 VGND.n236 VGND.n234 8.501
R323 VGND.n236 VGND.n235 8.501
R324 VGND.n462 VGND.n461 8.501
R325 VGND.n461 VGND.n6 8.501
R326 VGND.n52 VGND.n50 8.501
R327 VGND.n52 VGND.n51 8.501
R328 VGND.n261 VGND.n217 8.47111
R329 VGND.n260 VGND.n218 8.47111
R330 VGND.n259 VGND.n219 8.47111
R331 VGND.n257 VGND.n240 8.47111
R332 VGND.n257 VGND.n242 8.47111
R333 VGND.n257 VGND.n246 8.47111
R334 VGND.n257 VGND.n227 8.47111
R335 VGND.n257 VGND.n224 8.47111
R336 VGND.n257 VGND.n252 8.47111
R337 VGND.n4 VGND.n2 8.47111
R338 VGND.n17 VGND.n7 8.47111
R339 VGND.n459 VGND.n22 8.47111
R340 VGND.n459 VGND.n24 8.47111
R341 VGND.n459 VGND.n28 8.47111
R342 VGND.n459 VGND.n33 8.47111
R343 VGND.n457 VGND.n37 8.47111
R344 VGND.n456 VGND.n38 8.47111
R345 VGND.n455 VGND.n39 8.47111
R346 VGND.n453 VGND.n46 8.47111
R347 VGND.n453 VGND.n45 8.47111
R348 VGND.n453 VGND.n42 8.47111
R349 VGND.n270 VGND.n153 8.0799
R350 VGND.n419 uio_oe[7] 7.8231
R351 VGND.n434 VGND.n433 7.52168
R352 VGND.n434 VGND.n76 7.47272
R353 VGND.n278 VGND.n150 6.68645
R354 VGND.n437 VGND.n436 6.53659
R355 VGND.n160 VGND.n159 6.32858
R356 VGND.n396 VGND.n393 6.30123
R357 VGND.n189 VGND.n188 6.07977
R358 VGND.n193 VGND.n153 6.05718
R359 VGND.n270 VGND.n269 5.9638
R360 VGND.n237 VGND.n236 5.66778
R361 VGND.n461 VGND.n460 5.66778
R362 VGND.n52 VGND.n49 5.66778
R363 VGND.n236 VGND.n208 5.66767
R364 VGND.n461 VGND.n3 5.66767
R365 VGND.n52 VGND.n8 5.66767
R366 VGND.n257 VGND.n238 5.61485
R367 VGND.n257 VGND.n249 5.61485
R368 VGND.n459 VGND.n20 5.61485
R369 VGND.n459 VGND.n30 5.61485
R370 VGND.n453 VGND.n48 5.61485
R371 VGND.n288 VGND.n270 5.49409
R372 VGND.n289 VGND.n288 4.52382
R373 VGND.n287 VGND.n286 4.09378
R374 VGND.n420 VGND.n419 3.87689
R375 VGND.n425 VGND.n86 3.80865
R376 VGND.n273 VGND.n271 3.42765
R377 VGND.n263 VGND.n213 3.38768
R378 VGND.n279 VGND.n278 3.27628
R379 VGND.n296 VGND.n295 2.85446
R380 VGND.n324 VGND.n125 2.31911
R381 VGND.n125 VGND 2.31911
R382 VGND.n78 VGND.n77 2.27849
R383 VGND.n263 VGND.n262 1.97699
R384 VGND.n257 VGND.n256 1.97699
R385 VGND.n459 VGND.n458 1.97699
R386 VGND.n423 VGND.n422 1.81263
R387 VGND.n310 VGND.n140 1.72671
R388 VGND.n344 VGND.n343 1.47805
R389 VGND.n343 VGND.n342 1.4745
R390 VGND.n397 VGND 1.31963
R391 VGND.n257 VGND.n253 1.21402
R392 VGND.n459 VGND.n34 1.21402
R393 VGND.n263 VGND.n214 1.21402
R394 VGND.n278 VGND.n271 1.18201
R395 VGND.n396 VGND.n395 1.13055
R396 VGND.n263 VGND.n209 1.04263
R397 VGND.n257 VGND.n243 1.04263
R398 VGND.n257 VGND.n228 1.04263
R399 VGND.n257 VGND.n221 1.04263
R400 VGND.n459 VGND.n25 1.04263
R401 VGND.n459 VGND.n12 1.04263
R402 VGND.n459 VGND.n9 1.04263
R403 VGND.n453 VGND.n43 1.04263
R404 VGND.n257 VGND.n232 1.02715
R405 VGND.n257 VGND.n231 1.02715
R406 VGND.n459 VGND.n16 1.02715
R407 VGND.n459 VGND.n15 1.02715
R408 VGND.n453 VGND.n54 1.02715
R409 VGND.n453 VGND.n55 1.02715
R410 VGND.n86 VGND 1.01235
R411 VGND.n326 VGND.n125 0.936079
R412 VGND.n89 VGND.n88 0.882121
R413 VGND.n204 VGND.n125 0.851167
R414 VGND.n351 VGND.n350 0.8068
R415 VGND.n377 VGND.n376 0.803036
R416 VGND.n397 VGND.n396 0.620893
R417 VGND.n381 VGND.n380 0.598489
R418 VGND.n262 VGND.n261 0.585769
R419 VGND.n458 VGND.n457 0.585769
R420 VGND.n256 VGND.n1 0.52548
R421 VGND.n435 VGND.n434 0.518224
R422 VGND.n262 VGND.n216 0.477006
R423 VGND.n256 VGND.n255 0.477006
R424 VGND.n458 VGND.n36 0.477006
R425 VGND.n343 VGND.n112 0.473781
R426 VGND.n160 VGND.n153 0.464095
R427 VGND.n339 VGND.n112 0.434656
R428 VGND.n309 VGND.n141 0.423272
R429 VGND.n288 VGND.n287 0.364261
R430 VGND.n382 VGND.n381 0.352948
R431 VGND.n339 VGND.n338 0.347746
R432 VGND.n161 VGND.n160 0.328048
R433 VGND.n398 uo_out[5] 0.32522
R434 VGND.n399 uo_out[6] 0.32522
R435 VGND.n400 uo_out[7] 0.32522
R436 VGND.n401 uio_out[0] 0.32522
R437 VGND.n406 uio_out[2] 0.32522
R438 VGND.n407 uio_out[3] 0.32522
R439 VGND.n408 uio_out[4] 0.32522
R440 VGND.n409 uio_out[5] 0.32522
R441 VGND.n410 uio_out[6] 0.32522
R442 VGND.n411 uio_out[7] 0.32522
R443 VGND.n412 uio_oe[0] 0.32522
R444 VGND.n413 uio_oe[1] 0.32522
R445 VGND.n414 uio_oe[2] 0.32522
R446 VGND.n415 uio_oe[3] 0.32522
R447 VGND.n416 uio_oe[4] 0.32522
R448 VGND.n417 uio_oe[5] 0.32522
R449 VGND.n418 uio_oe[6] 0.32522
R450 VGND.n338 VGND.n337 0.289181
R451 VGND.n419 VGND.n86 0.273814
R452 VGND.n466 VGND.n0 0.27022
R453 VGND.n383 VGND.n382 0.2683
R454 VGND.n305 VGND.n141 0.2683
R455 VGND.n186 VGND.n161 0.256021
R456 VGND.n342 VGND.n110 0.250193
R457 VGND.n423 VGND.n420 0.243514
R458 VGND.n337 VGND.n336 0.243383
R459 VGND.n261 VGND.n260 0.241078
R460 VGND.n260 VGND.n259 0.241078
R461 VGND.n17 VGND.n2 0.241078
R462 VGND.n457 VGND.n456 0.241078
R463 VGND.n456 VGND.n455 0.241078
R464 VGND.n405 VGND.n404 0.22226
R465 VGND.n384 VGND.n383 0.221084
R466 VGND.n305 VGND.n304 0.221084
R467 VGND.n336 VGND.n335 0.216589
R468 VGND.n216 VGND.n213 0.208
R469 VGND.n287 VGND.n271 0.201227
R470 VGND.n87 VGND 0.196056
R471 VGND.n385 VGND.n384 0.193014
R472 VGND.n304 VGND.n303 0.193014
R473 VGND.n335 VGND.n334 0.189923
R474 VGND.n249 VGND 0.180825
R475 VGND.n30 VGND 0.180825
R476 VGND.n259 VGND.n258 0.180789
R477 VGND.n464 VGND.n2 0.180789
R478 VGND.n18 VGND.n17 0.180789
R479 VGND.n455 VGND.n454 0.180789
R480 VGND.n239 VGND.n238 0.177986
R481 VGND.n21 VGND.n20 0.177986
R482 VGND.n48 VGND.n47 0.177986
R483 VGND.n334 VGND.n333 0.177878
R484 VGND.n386 VGND.n385 0.172356
R485 VGND.n303 VGND.n302 0.172356
R486 VGND.n186 VGND.n185 0.165165
R487 VGND.n252 VGND.n251 0.163289
R488 VGND.n33 VGND.n32 0.163289
R489 VGND.n333 VGND.n332 0.161737
R490 VGND.n246 VGND.n245 0.159539
R491 VGND.n28 VGND.n27 0.159539
R492 VGND.n57 VGND.n42 0.159539
R493 VGND.n435 VGND.n73 0.158526
R494 VGND.n238 VGND.n220 0.158325
R495 VGND.n20 VGND.n19 0.158325
R496 VGND.n48 VGND.n40 0.158325
R497 VGND.n387 VGND.n386 0.155671
R498 VGND.n302 VGND.n301 0.155671
R499 VGND.n185 VGND.n184 0.152148
R500 VGND.n392 VGND.n391 0.150927
R501 VGND.n332 VGND.n331 0.149148
R502 VGND.n390 VGND.n90 0.149023
R503 VGND.n389 VGND.n91 0.147167
R504 VGND.n299 VGND.n147 0.147167
R505 VGND.n184 VGND.n183 0.145833
R506 VGND.n244 VGND.n242 0.145789
R507 VGND.n26 VGND.n24 0.145789
R508 VGND.n45 VGND.n44 0.145789
R509 VGND.n388 VGND.n92 0.144762
R510 VGND.n300 VGND.n146 0.144762
R511 VGND.n388 VGND.n387 0.143511
R512 VGND.n301 VGND.n300 0.143511
R513 VGND.n150 VGND.n149 0.143335
R514 VGND.n387 VGND.n93 0.14301
R515 VGND.n301 VGND.n145 0.14301
R516 VGND.n331 VGND.n330 0.142866
R517 VGND.n386 VGND.n94 0.1413
R518 VGND.n302 VGND.n144 0.1413
R519 VGND.n385 VGND.n95 0.13963
R520 VGND.n303 VGND.n143 0.13963
R521 VGND.n226 VGND.n224 0.138289
R522 VGND.n384 VGND.n96 0.138
R523 VGND.n304 VGND.n142 0.138
R524 VGND.n251 VGND.n249 0.137986
R525 VGND.n32 VGND.n30 0.137986
R526 VGND.n183 VGND.n182 0.136464
R527 VGND.n383 VGND.n97 0.136407
R528 VGND.n306 VGND.n305 0.136407
R529 VGND.n430 VGND.n429 0.134991
R530 VGND.n382 VGND.n98 0.134851
R531 VGND.n307 VGND.n141 0.134851
R532 VGND.n389 VGND.n388 0.134721
R533 VGND.n300 VGND.n299 0.134721
R534 VGND.n330 VGND.n329 0.133592
R535 VGND.n381 VGND.n99 0.13333
R536 VGND.n182 VGND.n181 0.131588
R537 VGND.n241 VGND.n240 0.130789
R538 VGND.n23 VGND.n22 0.130789
R539 VGND.n329 VGND.n328 0.127631
R540 VGND.n352 VGND.n109 0.127631
R541 VGND.n390 VGND.n389 0.127467
R542 VGND.n299 VGND.n298 0.127467
R543 VGND.n181 VGND.n180 0.126098
R544 VGND.n328 VGND.n327 0.123294
R545 VGND.n240 VGND.n239 0.123289
R546 VGND.n22 VGND.n21 0.123289
R547 VGND.n47 VGND.n46 0.123289
R548 VGND.n393 VGND.n392 0.122249
R549 VGND.n356 VGND.n109 0.122221
R550 VGND.n351 VGND.n110 0.122211
R551 VGND.n180 VGND.n179 0.121629
R552 VGND.n391 VGND.n390 0.121573
R553 VGND.n298 VGND.n297 0.121573
R554 VGND VGND.n227 0.120789
R555 VGND VGND.n224 0.120789
R556 VGND.n403 VGND.n46 0.120789
R557 VGND.n174 VGND.n173 0.119457
R558 VGND.n179 VGND.n178 0.118673
R559 VGND.n357 VGND.n356 0.117844
R560 VGND.n174 VGND.n73 0.117211
R561 VGND.n178 VGND.n177 0.114913
R562 VGND.n358 VGND.n357 0.114675
R563 VGND.n177 VGND.n176 0.113743
R564 VGND.n341 VGND.n112 0.112734
R565 VGND.n340 VGND.n339 0.112578
R566 VGND.n255 VGND.n252 0.112039
R567 VGND.n36 VGND.n33 0.112039
R568 VGND.n338 VGND.n113 0.111718
R569 VGND.n337 VGND.n114 0.111507
R570 VGND.n323 VGND.n322 0.111202
R571 VGND.n358 VGND.n107 0.111202
R572 VGND.n298 VGND.n148 0.11115
R573 VGND.n242 VGND.n241 0.110789
R574 VGND.n24 VGND.n23 0.110789
R575 VGND.n402 VGND.n45 0.110789
R576 VGND.n176 VGND.n175 0.110741
R577 VGND.n336 VGND.n115 0.110644
R578 VGND.n175 VGND.n174 0.110231
R579 VGND.n335 VGND.n116 0.110139
R580 VGND.n322 VGND.n321 0.110119
R581 VGND.n334 VGND.n117 0.109632
R582 VGND.n187 VGND.n186 0.109257
R583 VGND.n362 VGND.n107 0.109256
R584 VGND.n333 VGND.n118 0.109053
R585 VGND.n185 VGND.n162 0.10874
R586 VGND.n332 VGND.n119 0.10854
R587 VGND.n184 VGND.n163 0.108513
R588 VGND.n183 VGND.n164 0.108352
R589 VGND.n182 VGND.n165 0.108122
R590 VGND.n331 VGND.n120 0.108023
R591 VGND.n330 VGND.n121 0.107796
R592 VGND.n180 VGND.n167 0.107722
R593 VGND.n181 VGND.n166 0.107592
R594 VGND.n179 VGND.n168 0.107552
R595 VGND.n177 VGND.n170 0.10751
R596 VGND.n329 VGND.n122 0.107273
R597 VGND.n353 VGND.n352 0.107273
R598 VGND.n321 VGND.n320 0.107182
R599 VGND.n308 VGND.n139 0.107096
R600 VGND.n175 VGND.n172 0.107092
R601 VGND.n328 VGND.n123 0.107042
R602 VGND.n354 VGND.n109 0.107042
R603 VGND.n178 VGND.n169 0.10701
R604 VGND.n176 VGND.n171 0.106962
R605 VGND.n327 VGND.n124 0.10687
R606 VGND.n356 VGND.n355 0.10687
R607 VGND.n325 VGND.n126 0.106635
R608 VGND.n357 VGND.n108 0.106635
R609 VGND.n379 VGND.n101 0.106426
R610 VGND.n363 VGND.n362 0.106367
R611 VGND.n323 VGND.n127 0.1061
R612 VGND.n359 VGND.n358 0.1061
R613 VGND.n321 VGND.n129 0.10604
R614 VGND.n362 VGND.n361 0.10604
R615 VGND.n319 VGND.n131 0.105977
R616 VGND.n365 VGND.n364 0.105977
R617 VGND.n314 VGND.n136 0.105973
R618 VGND.n372 VGND.n103 0.105973
R619 VGND.n322 VGND.n128 0.10592
R620 VGND.n360 VGND.n107 0.10592
R621 VGND.n378 VGND.n102 0.105907
R622 VGND.n315 VGND.n135 0.105848
R623 VGND.n371 VGND.n370 0.105848
R624 VGND.n313 VGND.n137 0.10578
R625 VGND.n374 VGND.n373 0.10578
R626 VGND.n318 VGND.n132 0.105731
R627 VGND.n366 VGND.n105 0.105731
R628 VGND.n320 VGND.n319 0.105665
R629 VGND.n316 VGND.n134 0.105663
R630 VGND.n369 VGND.n104 0.105663
R631 VGND.n317 VGND.n133 0.105542
R632 VGND.n368 VGND.n367 0.105542
R633 VGND.n320 VGND.n130 0.105493
R634 VGND.n363 VGND.n106 0.105493
R635 VGND.n364 VGND.n363 0.104886
R636 VGND.n296 VGND.n150 0.104495
R637 VGND.n319 VGND.n318 0.104166
R638 VGND.n364 VGND.n105 0.104166
R639 VGND.n404 uio_out[1] 0.10346
R640 VGND.n227 VGND.n226 0.103289
R641 VGND.n317 VGND.n316 0.102551
R642 VGND.n318 VGND.n317 0.102053
R643 VGND.n368 VGND.n105 0.102053
R644 VGND.n324 VGND.n323 0.101891
R645 VGND.n369 VGND.n368 0.101858
R646 VGND.n316 VGND.n315 0.101493
R647 VGND.n370 VGND.n369 0.101493
R648 VGND.n315 VGND.n314 0.100967
R649 VGND.n370 VGND.n103 0.100967
R650 VGND.n312 VGND.n311 0.100958
R651 VGND.n313 VGND.n312 0.100445
R652 VGND.n379 VGND.n378 0.100376
R653 VGND.n314 VGND.n313 0.100187
R654 VGND.n374 VGND.n103 0.100187
R655 VGND.n73 VGND.n72 0.0973571
R656 VGND.n246 VGND.n244 0.095789
R657 VGND.n28 VGND.n26 0.095789
R658 VGND.n44 VGND.n42 0.095789
R659 VGND.n429 VGND.n428 0.0954338
R660 VGND.n424 VGND.n85 0.0928432
R661 VGND.n327 VGND.n326 0.0895217
R662 VGND.n433 VGND.n432 0.0873393
R663 VGND.n391 VGND.n89 0.085643
R664 VGND.n204 VGND 0.0854123
R665 VGND.n258 VGND.n220 0.083
R666 VGND.n19 VGND.n18 0.083
R667 VGND.n454 VGND.n40 0.083
R668 VGND.n312 VGND.n138 0.0814084
R669 VGND.n380 VGND.n100 0.0802603
R670 VGND.n101 VGND.n100 0.0782828
R671 VGND.n465 VGND.n464 0.078
R672 VGND.n392 VGND.n90 0.0779701
R673 VGND.n378 VGND.n377 0.0771258
R674 VGND.n352 VGND.n351 0.0762778
R675 VGND.n428 VGND.n427 0.0754235
R676 VGND.n91 VGND.n90 0.0751329
R677 VGND.n424 VGND.n423 0.0739655
R678 VGND.n148 VGND.n147 0.0735315
R679 VGND.n92 VGND.n91 0.0731
R680 VGND.n147 VGND.n146 0.0731
R681 VGND.n432 VGND.n79 0.0724725
R682 VGND.n93 VGND.n92 0.0701066
R683 VGND.n146 VGND.n145 0.0701066
R684 VGND.n94 VGND.n93 0.067836
R685 VGND.n145 VGND.n144 0.067836
R686 VGND.n311 VGND.n310 0.0669444
R687 VGND.n95 VGND.n94 0.06562
R688 VGND.n144 VGND.n143 0.06562
R689 VGND.n263 VGND.n210 0.0650946
R690 VGND.n257 VGND.n248 0.0650946
R691 VGND.n257 VGND.n222 0.0650946
R692 VGND.n459 VGND.n10 0.0650946
R693 VGND.n96 VGND.n95 0.0634565
R694 VGND.n143 VGND.n142 0.0634565
R695 VGND.n427 VGND.n426 0.0614573
R696 VGND.n289 VGND 0.061
R697 VGND.n269 VGND 0.061
R698 VGND.n395 VGND 0.061
R699 VGND.n77 VGND 0.061
R700 VGND.n76 VGND 0.061
R701 VGND.n437 VGND 0.061
R702 VGND.n189 VGND 0.061
R703 VGND.n159 VGND 0.061
R704 VGND.n422 VGND 0.061
R705 VGND.n88 VGND 0.061
R706 VGND.n97 VGND.n96 0.061
R707 VGND.n140 VGND 0.061
R708 VGND.n295 VGND 0.061
R709 VGND.n279 VGND 0.061
R710 VGND.n273 VGND 0.061
R711 VGND.n306 VGND.n142 0.061
R712 VGND.n344 VGND 0.061
R713 VGND.n350 VGND 0.061
R714 VGND.n376 VGND 0.061
R715 VGND.n193 VGND 0.061
R716 VGND.n286 VGND 0.061
R717 VGND.n81 VGND.n80 0.0607651
R718 VGND.n229 VGND 0.0605
R719 VGND VGND.n13 0.0605
R720 VGND.n58 VGND 0.0605
R721 VGND.n393 VGND.n89 0.060354
R722 VGND.n98 VGND.n97 0.0589402
R723 VGND.n307 VGND.n306 0.0589402
R724 VGND.n426 VGND.n425 0.0585315
R725 VGND.n297 VGND.n149 0.0568276
R726 VGND.n99 VGND.n98 0.0565916
R727 VGND.n308 VGND.n307 0.0565916
R728 uo_out[4] VGND.n466 0.0555
R729 VGND.n85 VGND.n84 0.0547113
R730 VGND.n100 VGND.n99 0.0546283
R731 VGND.n430 VGND.n81 0.0545351
R732 VGND.n432 VGND.n431 0.0537058
R733 VGND.n138 VGND.n137 0.0535756
R734 VGND.n380 VGND.n379 0.0505564
R735 VGND.n102 VGND.n101 0.0497148
R736 VGND.n84 VGND.n83 0.0483673
R737 VGND.n309 VGND.n308 0.048347
R738 VGND.n373 VGND.n102 0.0478846
R739 VGND.n137 VGND.n136 0.04594
R740 VGND.n373 VGND.n372 0.04594
R741 VGND VGND.n87 0.0445
R742 VGND.n136 VGND.n135 0.0440235
R743 VGND.n372 VGND.n371 0.0440235
R744 VGND.n465 VGND.n1 0.043
R745 VGND.n135 VGND.n134 0.0421344
R746 VGND.n371 VGND.n104 0.0421344
R747 VGND.n83 VGND.n82 0.0419304
R748 VGND.n173 VGND.n72 0.0411957
R749 VGND.n311 VGND.n139 0.0409767
R750 VGND.n134 VGND.n133 0.0401312
R751 VGND.n367 VGND.n104 0.0401312
R752 VGND.n149 VGND.n148 0.0397586
R753 VGND.n133 VGND.n132 0.0386127
R754 VGND.n367 VGND.n366 0.0386127
R755 VGND.n310 VGND.n309 0.0384989
R756 VGND.n132 VGND.n131 0.0365
R757 VGND.n366 VGND.n365 0.0365
R758 VGND.n436 VGND.n72 0.0356429
R759 VGND.n173 VGND.n172 0.0355141
R760 VGND.n131 VGND.n130 0.0351481
R761 VGND.n365 VGND.n106 0.0351481
R762 VGND.n172 VGND.n171 0.0337308
R763 VGND.n130 VGND.n129 0.0332724
R764 VGND.n361 VGND.n106 0.0332724
R765 VGND.n342 VGND.n341 0.032543
R766 VGND.n420 VGND.n397 0.0319281
R767 VGND.n171 VGND.n170 0.0317753
R768 VGND.n129 VGND.n128 0.0313454
R769 VGND.n361 VGND.n360 0.0313454
R770 VGND.n353 VGND.n110 0.0307408
R771 VGND.n170 VGND.n169 0.0302379
R772 VGND.n128 VGND.n127 0.0299334
R773 VGND.n360 VGND.n359 0.0299334
R774 VGND.n326 VGND.n325 0.0298333
R775 VGND.n169 VGND.n168 0.0283213
R776 VGND.n127 VGND.n126 0.0279441
R777 VGND.n359 VGND.n108 0.0279441
R778 VGND.n80 VGND.n79 0.0273067
R779 VGND.n168 VGND.n167 0.0266297
R780 VGND.n126 VGND.n124 0.0263649
R781 VGND.n355 VGND.n108 0.0263649
R782 VGND.n139 VGND.n138 0.0255726
R783 VGND.n167 VGND.n166 0.024961
R784 VGND.n124 VGND.n123 0.0247963
R785 VGND.n355 VGND.n354 0.0247963
R786 VGND.n166 VGND.n165 0.0233919
R787 VGND.n377 VGND.n374 0.02322
R788 VGND.n123 VGND.n122 0.0231622
R789 VGND.n354 VGND.n353 0.0231622
R790 VGND.n165 VGND.n164 0.0218333
R791 VGND.n245 VGND.n229 0.02175
R792 VGND.n27 VGND.n13 0.02175
R793 VGND.n58 VGND.n57 0.02175
R794 VGND.n122 VGND.n121 0.02162
R795 VGND.n436 VGND.n435 0.0212439
R796 VGND.n297 VGND.n296 0.0200345
R797 VGND.n164 VGND.n163 0.0199247
R798 VGND.n121 VGND.n120 0.0197957
R799 VGND.n163 VGND.n162 0.0186867
R800 VGND.n120 VGND.n119 0.0185662
R801 VGND.n431 VGND.n430 0.0170759
R802 VGND.n187 VGND.n162 0.0168721
R803 VGND.n119 VGND.n118 0.016764
R804 VGND.n0 uo_out[5] 0.0157601
R805 VGND.n398 uo_out[6] 0.0157601
R806 VGND.n399 uo_out[7] 0.0157601
R807 VGND.n400 uio_out[0] 0.0157601
R808 VGND.n401 uio_out[1] 0.0157601
R809 VGND.n405 uio_out[2] 0.0157601
R810 VGND.n406 uio_out[3] 0.0157601
R811 VGND.n407 uio_out[4] 0.0157601
R812 VGND.n408 uio_out[5] 0.0157601
R813 VGND.n409 uio_out[6] 0.0157601
R814 VGND.n410 uio_out[7] 0.0157601
R815 VGND.n411 uio_oe[0] 0.0157601
R816 VGND.n412 uio_oe[1] 0.0157601
R817 VGND.n413 uio_oe[2] 0.0157601
R818 VGND.n414 uio_oe[3] 0.0157601
R819 VGND.n415 uio_oe[4] 0.0157601
R820 VGND.n416 uio_oe[5] 0.0157601
R821 VGND.n417 uio_oe[6] 0.0157601
R822 VGND.n418 uio_oe[7] 0.0157601
R823 VGND.n79 VGND.n78 0.0153179
R824 VGND.n188 VGND.n187 0.0150695
R825 VGND.n118 VGND.n117 0.0149737
R826 VGND.n117 VGND.n116 0.0138158
R827 uo_out[5] VGND.n0 0.0137
R828 uo_out[6] VGND.n398 0.0137
R829 uo_out[7] VGND.n399 0.0137
R830 uio_out[0] VGND.n400 0.0137
R831 uio_out[1] VGND.n401 0.0137
R832 uio_out[2] VGND.n405 0.0137
R833 uio_out[3] VGND.n406 0.0137
R834 uio_out[4] VGND.n407 0.0137
R835 uio_out[5] VGND.n408 0.0137
R836 uio_out[6] VGND.n409 0.0137
R837 uio_out[7] VGND.n410 0.0137
R838 uio_oe[0] VGND.n411 0.0137
R839 uio_oe[1] VGND.n412 0.0137
R840 uio_oe[2] VGND.n413 0.0137
R841 uio_oe[3] VGND.n414 0.0137
R842 uio_oe[4] VGND.n415 0.0137
R843 uio_oe[5] VGND.n416 0.0137
R844 uio_oe[6] VGND.n417 0.0137
R845 uio_oe[7] VGND.n418 0.0137
R846 VGND.n325 VGND.n324 0.0132838
R847 VGND.n82 VGND.n81 0.0121797
R848 VGND.n116 VGND.n115 0.012041
R849 VGND.n115 VGND.n114 0.0105654
R850 VGND.n403 VGND.n402 0.0105
R851 VGND.n433 VGND.n78 0.00934499
R852 VGND.n425 VGND.n424 0.00920833
R853 VGND.n114 VGND.n113 0.00883987
R854 VGND.n429 VGND.n82 0.00874622
R855 VGND.n428 VGND.n83 0.0077971
R856 VGND.n340 VGND.n113 0.00737948
R857 VGND.n427 VGND.n84 0.00643951
R858 VGND.n341 VGND.n340 0.00594625
R859 VGND.n188 VGND.n161 0.00588981
R860 VGND.n431 VGND.n80 0.00446192
R861 VGND.n426 VGND.n85 0.00434654
R862 VGND.n237 VGND.n219 0.00166667
R863 VGND.n460 VGND.n7 0.00166667
R864 VGND.n49 VGND.n39 0.00166667
R865 VGND.n257 VGND.n237 0.00133332
R866 VGND.n460 VGND.n459 0.00133332
R867 VGND.n453 VGND.n49 0.00133332
R868 VGND.n217 VGND.n208 0.001
R869 VGND.n234 VGND.n217 0.001
R870 VGND.n235 VGND.n218 0.001
R871 VGND.n463 VGND.n3 0.001
R872 VGND.n463 VGND.n462 0.001
R873 VGND.n6 VGND.n4 0.001
R874 VGND.n37 VGND.n8 0.001
R875 VGND.n50 VGND.n37 0.001
R876 VGND.n51 VGND.n38 0.001
R877 VGND.n263 VGND.n208 0.001
R878 VGND.n234 VGND.n218 0.001
R879 VGND.n235 VGND.n219 0.001
R880 VGND.n257 VGND.n3 0.001
R881 VGND.n462 VGND.n4 0.001
R882 VGND.n7 VGND.n6 0.001
R883 VGND.n459 VGND.n8 0.001
R884 VGND.n50 VGND.n38 0.001
R885 VGND.n51 VGND.n39 0.001
R886 uo_out[1].n3 uo_out[1].t2 15.0005
R887 uo_out[1] uo_out[1].n3 13.4668
R888 uo_out[1].n2 uo_out[1].n1 9.01747
R889 uo_out[1].n0 uo_out[1].t1 8.53421
R890 uo_out[1].n2 uo_out[1] 6.6565
R891 uo_out[1].n0 uo_out[1].t0 6.13626
R892 uo_out[1].n1 uo_out[1].n0 0.100612
R893 uo_out[1].n1 uo_out[1] 0.0585899
R894 uo_out[1].n3 uo_out[1] 0.04098
R895 uo_out[1] uo_out[1].n2 0.00678571
R896 VDPWR.n201 VDPWR.n200 19.7403
R897 VDPWR.n200 VDPWR.n199 18.0005
R898 VDPWR.n224 VDPWR.t30 17.378
R899 VDPWR.n209 VDPWR.t31 17.378
R900 VDPWR.n1 VDPWR.t32 17.378
R901 VDPWR.n225 VDPWR.t6 17.3693
R902 VDPWR.n207 VDPWR.t23 17.3693
R903 VDPWR.n19 VDPWR.t21 17.3693
R904 VDPWR.n213 VDPWR.t11 17.1422
R905 VDPWR.n232 VDPWR.n16 17.0005
R906 VDPWR.n232 VDPWR.n18 17.0005
R907 VDPWR.n224 VDPWR.t1 17.0005
R908 VDPWR.n209 VDPWR.t15 17.0005
R909 VDPWR.n227 VDPWR.n211 17.0005
R910 VDPWR.n227 VDPWR.n214 17.0005
R911 VDPWR.n227 VDPWR.n215 17.0005
R912 VDPWR.n227 VDPWR.n202 17.0005
R913 VDPWR.n1 VDPWR.t18 17.0005
R914 VDPWR.n232 VDPWR.n13 17.0005
R915 VDPWR.n233 VDPWR.n232 17.0005
R916 VDPWR.n232 VDPWR.n0 17.0005
R917 VDPWR.n228 VDPWR.n227 17.0005
R918 VDPWR.n200 VDPWR.n197 9.61849
R919 VDPWR.n195 VDPWR.n194 9.2117
R920 VDPWR.n191 VDPWR.n35 9.18823
R921 VDPWR.n195 VDPWR.n30 9.18823
R922 VDPWR.n195 VDPWR.n29 9.05079
R923 VDPWR.n192 VDPWR.n191 9.0005
R924 VDPWR.n193 VDPWR.n30 9.0005
R925 VDPWR.n192 VDPWR.n33 9.0005
R926 VDPWR.n193 VDPWR.n29 9.0005
R927 VDPWR.n192 VDPWR.n31 9.0005
R928 VDPWR.n194 VDPWR.n193 9.0005
R929 VDPWR.n177 VDPWR.n39 9.0005
R930 VDPWR.n180 VDPWR.n179 9.0005
R931 VDPWR.n178 VDPWR.n38 9.0005
R932 VDPWR.n222 VDPWR.t9 8.80285
R933 VDPWR.n22 VDPWR.t3 8.80285
R934 VDPWR.n10 VDPWR.t28 8.80285
R935 VDPWR.t0 VDPWR.n203 8.501
R936 VDPWR.n227 VDPWR.n219 8.47111
R937 VDPWR.n227 VDPWR.n221 8.47111
R938 VDPWR.n232 VDPWR.n11 8.47111
R939 VDPWR.n232 VDPWR.n5 8.47111
R940 VDPWR.n232 VDPWR.n3 8.47111
R941 VDPWR.n230 VDPWR.n23 8.47111
R942 VDPWR.n229 VDPWR.n24 8.47111
R943 VDPWR.n220 VDPWR.t7 6.07323
R944 VDPWR.n4 VDPWR.t2 6.07323
R945 VDPWR.n12 VDPWR.t26 6.07323
R946 VDPWR.n157 VDPWR.n156 6.01045
R947 VDPWR.n15 VDPWR.t17 5.98925
R948 VDPWR.n17 VDPWR.t16 5.98882
R949 VDPWR.n218 VDPWR.t34 5.98882
R950 VDPWR.n216 VDPWR.t33 5.98882
R951 VDPWR.n7 VDPWR.t12 5.98882
R952 VDPWR.n6 VDPWR.t13 5.98882
R953 VDPWR.n41 ring_0/inverter_ring_0/skullfet_inverter_0.VDPWR 5.96901
R954 VDPWR.n78 VDPWR.n77 5.84778
R955 VDPWR.n232 VDPWR.n14 5.61485
R956 VDPWR.n227 VDPWR.n212 5.61485
R957 VDPWR.n227 VDPWR.n217 5.61485
R958 VDPWR.n232 VDPWR.n8 5.61485
R959 VDPWR.n232 VDPWR.n231 5.61485
R960 VDPWR.n152 VDPWR.n151 5.21746
R961 VDPWR.n160 ring_0/inverter_ring_0/skullfet_inverter_0.VDPWR 4.73
R962 VDPWR.n171 ring_0/inverter_ring_0/skullfet_inverter_0.VDPWR 4.6152
R963 VDPWR.n76 VDPWR.n35 4.53071
R964 VDPWR.n190 VDPWR.n34 4.51901
R965 VDPWR.n189 VDPWR.n28 4.50989
R966 VDPWR.n159 ring_0/inverter_ring_0/skullfet_inverter_0.VDPWR 4.13588
R967 VDPWR.n158 ring_0/inverter_ring_0/skullfet_inverter_0.VDPWR 3.92388
R968 VDPWR.n156 ring_0/inverter_ring_0/skullfet_inverter_0.VDPWR 3.88095
R969 VDPWR.n157 ring_0/inverter_ring_0/skullfet_inverter_0.VDPWR 3.84419
R970 VDPWR.n183 VDPWR.n26 3.70926
R971 VDPWR.n197 VDPWR.n196 3.69606
R972 VDPWR.n187 ring_0/inverter_ring_0/skullfet_inverter_0.VDPWR 3.66357
R973 VDPWR.n155 ring_0/inverter_ring_0/skullfet_inverter_0.VDPWR 3.41222
R974 VDPWR.n232 VDPWR.n20 3.30723
R975 VDPWR.n227 VDPWR.n208 3.30688
R976 VDPWR.n188 ring_0/inverter_ring_0/skullfet_inverter_0.VDPWR 3.28289
R977 VDPWR.n40 VDPWR.n39 3.0005
R978 VDPWR.n180 VDPWR.n176 3.0005
R979 VDPWR.n174 VDPWR.n38 3.0005
R980 VDPWR.n77 ring_0/inverter_ring_0/skullfet_inverter_0.VDPWR 2.98934
R981 VDPWR.n227 VDPWR.n226 2.72512
R982 VDPWR.n173 VDPWR.n171 2.5318
R983 VDPWR.n74 ring_0/inverter_ring_0/skullfet_inverter_0.VDPWR 2.53128
R984 VDPWR.n91 VDPWR.n90 2.46388
R985 VDPWR.n227 VDPWR.n206 2.29781
R986 VDPWR.n35 VDPWR.n32 2.27162
R987 VDPWR.n185 VDPWR.n184 2.26628
R988 VDPWR.n196 VDPWR.n195 2.2505
R989 VDPWR.n192 VDPWR.n32 2.2505
R990 VDPWR.n193 VDPWR.n27 2.2505
R991 VDPWR.n184 VDPWR.n183 2.2505
R992 VDPWR.n182 VDPWR.n38 2.2505
R993 VDPWR.n154 ring_0/inverter_ring_0/skullfet_inverter_0.VDPWR 2.15229
R994 VDPWR.n205 VDPWR 2.0605
R995 VDPWR.n87 ring_0/inverter_ring_0/skullfet_inverter_0.VDPWR 1.94477
R996 VDPWR.n153 ring_0/inverter_ring_0/skullfet_inverter_0.VDPWR 1.74056
R997 VDPWR.n151 ring_0/inverter_ring_0/skullfet_inverter_0.VDPWR 1.53994
R998 VDPWR.n25 VDPWR 1.53643
R999 VDPWR.n152 ring_0/inverter_ring_0/skullfet_inverter_0.VDPWR 1.39911
R1000 VDPWR.n46 ring_0/inverter_ring_0/skullfet_inverter_0.VDPWR 1.19117
R1001 VDPWR.n89 ring_0/inverter_ring_0/skullfet_inverter_0.VDPWR 1.1824
R1002 VDPWR.n182 VDPWR.n181 1.14638
R1003 VDPWR.n155 VDPWR.n154 1.035
R1004 VDPWR.n26 VDPWR 0.977695
R1005 VDPWR.n151 VDPWR.n150 0.923201
R1006 VDPWR.n118 ring_0/inverter_ring_0/skullfet_inverter_0.VDPWR 0.895684
R1007 VDPWR.n66 ring_0/inverter_ring_0/skullfet_inverter_0.VDPWR 0.886
R1008 VDPWR.n10 VDPWR.n9 0.854038
R1009 VDPWR.n223 VDPWR.n222 0.851125
R1010 VDPWR.n225 VDPWR.n223 0.805789
R1011 VDPWR.n19 VDPWR.n9 0.803932
R1012 VDPWR.n232 VDPWR.n9 0.802654
R1013 VDPWR.n227 VDPWR.n223 0.800901
R1014 VDPWR.n89 VDPWR.n88 0.767737
R1015 VDPWR.n161 VDPWR.n159 0.762233
R1016 VDPWR.n198 VDPWR 0.543
R1017 VDPWR.n80 VDPWR.n79 0.531002
R1018 VDPWR.n127 VDPWR.n53 0.507992
R1019 VDPWR.n226 VDPWR.n224 0.410237
R1020 VDPWR.t0 VDPWR.n21 0.40574
R1021 VDPWR.n154 VDPWR.n153 0.393052
R1022 VDPWR.n206 VDPWR.n205 0.392462
R1023 VDPWR.n226 VDPWR.n225 0.389189
R1024 VDPWR.n207 VDPWR.n206 0.373903
R1025 VDPWR.n158 VDPWR.n157 0.363276
R1026 VDPWR.n197 VDPWR.n26 0.353505
R1027 VDPWR.n204 VDPWR.t0 0.341
R1028 VDPWR.n20 VDPWR.n19 0.336433
R1029 VDPWR.n208 VDPWR.n207 0.335808
R1030 VDPWR.n188 VDPWR.n187 0.334929
R1031 VDPWR.n153 VDPWR.n152 0.332665
R1032 VDPWR.n210 VDPWR.n208 0.332049
R1033 VDPWR.n20 VDPWR.n2 0.331445
R1034 VDPWR.n91 VDPWR.n65 0.330588
R1035 VDPWR.n156 VDPWR.n155 0.323555
R1036 VDPWR.n189 VDPWR.n188 0.312824
R1037 VDPWR.n90 VDPWR.n89 0.305164
R1038 VDPWR.n231 VDPWR.n230 0.300775
R1039 VDPWR.n159 VDPWR.n158 0.289257
R1040 VDPWR.n131 VDPWR.n53 0.2887
R1041 VDPWR.n95 VDPWR.n65 0.280623
R1042 VDPWR.n81 VDPWR.n70 0.251853
R1043 VDPWR.n82 VDPWR.n69 0.2469
R1044 VDPWR.n83 VDPWR.n68 0.24161
R1045 VDPWR.n149 VDPWR.n148 0.24161
R1046 VDPWR.n230 VDPWR.n229 0.241078
R1047 VDPWR.n96 VDPWR.n95 0.240286
R1048 VDPWR.n85 VDPWR.n84 0.237849
R1049 VDPWR.n147 VDPWR.n47 0.237849
R1050 VDPWR.n86 VDPWR.n67 0.234669
R1051 VDPWR.n146 VDPWR.n145 0.234669
R1052 VDPWR.n213 VDPWR.n212 0.234575
R1053 VDPWR.n144 VDPWR.n48 0.231561
R1054 VDPWR.n75 VDPWR.n72 0.230306
R1055 VDPWR.n143 VDPWR.n142 0.226786
R1056 VDPWR.n132 VDPWR.n131 0.225081
R1057 VDPWR.n141 VDPWR.n49 0.22337
R1058 VDPWR.n140 VDPWR.n139 0.219324
R1059 VDPWR.n138 VDPWR.n50 0.217223
R1060 VDPWR.n137 VDPWR.n136 0.213359
R1061 VDPWR.n80 VDPWR.n71 0.212767
R1062 VDPWR.n194 VDPWR.n31 0.2117
R1063 VDPWR.n135 VDPWR.n51 0.211333
R1064 VDPWR.n134 VDPWR.n133 0.208253
R1065 VDPWR.n97 VDPWR.n96 0.204702
R1066 VDPWR.n132 VDPWR.n52 0.204642
R1067 VDPWR.n131 VDPWR.n130 0.202722
R1068 VDPWR.n79 VDPWR.n78 0.201278
R1069 VDPWR.n129 VDPWR.n53 0.19982
R1070 VDPWR.n97 VDPWR.n63 0.187779
R1071 VDPWR.n231 VDPWR.n22 0.185825
R1072 VDPWR.n229 VDPWR.n228 0.180789
R1073 VDPWR.n212 VDPWR 0.180486
R1074 VDPWR.n133 VDPWR.n132 0.177266
R1075 VDPWR.n88 VDPWR.n67 0.175862
R1076 VDPWR.n101 VDPWR.n63 0.175509
R1077 VDPWR.n126 VDPWR.n54 0.173049
R1078 VDPWR.n125 VDPWR.n124 0.172207
R1079 VDPWR.n219 VDPWR.n218 0.172039
R1080 VDPWR.n7 VDPWR.n5 0.172039
R1081 VDPWR.n123 VDPWR.n55 0.171374
R1082 VDPWR.n122 VDPWR.n121 0.169731
R1083 VDPWR.n120 VDPWR.n56 0.168921
R1084 VDPWR.n162 VDPWR.n161 0.167396
R1085 VDPWR.n119 VDPWR.n118 0.167325
R1086 VDPWR.n117 VDPWR.n57 0.166538
R1087 VDPWR.n116 VDPWR.n115 0.165758
R1088 VDPWR.n150 VDPWR.n149 0.165337
R1089 VDPWR.n114 VDPWR.n58 0.164986
R1090 VDPWR.n113 VDPWR.n112 0.164221
R1091 VDPWR.n111 VDPWR.n59 0.163463
R1092 VDPWR.n73 VDPWR.n72 0.162204
R1093 VDPWR.n108 VDPWR.n60 0.161968
R1094 VDPWR.n110 VDPWR.n109 0.161968
R1095 VDPWR.n105 VDPWR.n61 0.161231
R1096 VDPWR.n107 VDPWR.n106 0.161231
R1097 VDPWR.n101 VDPWR.n100 0.159776
R1098 VDPWR.n102 VDPWR.n62 0.159776
R1099 VDPWR.n104 VDPWR.n103 0.159776
R1100 VDPWR.n98 VDPWR.n97 0.159059
R1101 VDPWR.n99 VDPWR.n63 0.159059
R1102 VDPWR.n93 VDPWR.n65 0.158348
R1103 VDPWR.n95 VDPWR.n94 0.158348
R1104 VDPWR.n96 VDPWR.n64 0.158348
R1105 VDPWR.n186 VDPWR.n36 0.158044
R1106 VDPWR.n102 VDPWR.n101 0.157911
R1107 VDPWR.n133 VDPWR.n51 0.157621
R1108 VDPWR.n92 VDPWR.n91 0.154546
R1109 VDPWR.n128 VDPWR.n127 0.15242
R1110 VDPWR.n170 VDPWR.n169 0.152188
R1111 VDPWR.n103 VDPWR.n102 0.147308
R1112 VDPWR.n190 VDPWR.n30 0.147167
R1113 VDPWR.n103 VDPWR.n61 0.14126
R1114 VDPWR.n137 VDPWR.n51 0.141098
R1115 VDPWR.n221 VDPWR.n220 0.140789
R1116 VDPWR.n4 VDPWR.n3 0.140789
R1117 VDPWR.n12 VDPWR.n11 0.140789
R1118 VDPWR.n210 VDPWR.n209 0.136382
R1119 VDPWR.n2 VDPWR.n1 0.136382
R1120 VDPWR.n164 VDPWR.n163 0.135022
R1121 VDPWR.n107 VDPWR.n61 0.133682
R1122 VDPWR.n17 VDPWR.n14 0.129236
R1123 VDPWR.n218 VDPWR.n217 0.129236
R1124 VDPWR.n8 VDPWR.n7 0.129236
R1125 VDPWR.n15 VDPWR.n14 0.128325
R1126 VDPWR.n217 VDPWR.n216 0.128325
R1127 VDPWR.n8 VDPWR.n6 0.128325
R1128 VDPWR.n108 VDPWR.n107 0.127233
R1129 VDPWR.n71 VDPWR.n70 0.1269
R1130 VDPWR.n138 VDPWR.n137 0.126475
R1131 VDPWR.n109 VDPWR.n108 0.123269
R1132 VDPWR.n109 VDPWR.n59 0.121562
R1133 VDPWR.n76 VDPWR.n31 0.1171
R1134 VDPWR.n113 VDPWR.n59 0.116891
R1135 VDPWR.n139 VDPWR.n138 0.116337
R1136 VDPWR.n222 VDPWR.n221 0.115789
R1137 VDPWR.n22 VDPWR.n3 0.115789
R1138 VDPWR.n11 VDPWR.n10 0.115789
R1139 VDPWR.n114 VDPWR.n113 0.114401
R1140 VDPWR.n16 VDPWR.n15 0.113
R1141 VDPWR.n216 VDPWR.n215 0.113
R1142 VDPWR.n6 VDPWR.n0 0.113
R1143 VDPWR.n18 VDPWR.n17 0.11175
R1144 VDPWR.n115 VDPWR.n114 0.111106
R1145 VDPWR.n115 VDPWR.n57 0.110556
R1146 VDPWR.n119 VDPWR.n57 0.108981
R1147 VDPWR.n120 VDPWR.n119 0.108669
R1148 VDPWR.n121 VDPWR.n120 0.108583
R1149 VDPWR.n139 VDPWR.n49 0.108277
R1150 VDPWR.n121 VDPWR.n55 0.108072
R1151 VDPWR.n126 VDPWR.n125 0.107345
R1152 VDPWR.n125 VDPWR.n55 0.107234
R1153 VDPWR.n143 VDPWR.n49 0.103826
R1154 VDPWR.n220 VDPWR.n219 0.100789
R1155 VDPWR.n5 VDPWR.n4 0.100789
R1156 VDPWR.n144 VDPWR.n143 0.0994295
R1157 VDPWR.n145 VDPWR.n144 0.096586
R1158 VDPWR.n168 VDPWR.n167 0.0942964
R1159 VDPWR.n84 VDPWR.n67 0.0929227
R1160 VDPWR.n145 VDPWR.n47 0.0929227
R1161 VDPWR.n161 VDPWR.n160 0.0929187
R1162 VDPWR.n84 VDPWR.n83 0.0912154
R1163 VDPWR.n149 VDPWR.n47 0.0912154
R1164 VDPWR.n163 VDPWR.n44 0.0893224
R1165 VDPWR.n83 VDPWR.n82 0.0884738
R1166 VDPWR.n199 VDPWR.n198 0.088
R1167 VDPWR.n82 VDPWR.n81 0.0871337
R1168 VDPWR.n81 VDPWR.n80 0.0864426
R1169 VDPWR.n160 VDPWR.n45 0.0849682
R1170 VDPWR.n70 VDPWR.n69 0.0816497
R1171 VDPWR.n73 VDPWR.n71 0.0787288
R1172 VDPWR.n69 VDPWR.n68 0.0781471
R1173 VDPWR.n148 VDPWR.n46 0.0781471
R1174 VDPWR.n164 VDPWR.n45 0.0761377
R1175 VDPWR.n85 VDPWR.n68 0.0757832
R1176 VDPWR.n148 VDPWR.n147 0.0757832
R1177 VDPWR.n86 VDPWR.n85 0.0734143
R1178 VDPWR.n147 VDPWR.n146 0.0734143
R1179 VDPWR.n165 VDPWR.n164 0.0722058
R1180 VDPWR.n201 VDPWR.n25 0.0717963
R1181 VDPWR.n42 VDPWR.n41 0.071653
R1182 VDPWR.n87 VDPWR.n86 0.071596
R1183 VDPWR.n146 VDPWR.n48 0.071596
R1184 VDPWR.n142 VDPWR.n48 0.0688352
R1185 VDPWR.n128 VDPWR.n54 0.0683607
R1186 VDPWR.n167 VDPWR.n42 0.0679195
R1187 VDPWR.n142 VDPWR.n141 0.0662582
R1188 VDPWR.n79 VDPWR.n72 0.0656852
R1189 VDPWR.n205 VDPWR.n202 0.0656852
R1190 VDPWR.n141 VDPWR.n140 0.0641087
R1191 VDPWR.n150 VDPWR.n46 0.0637952
R1192 VDPWR.n172 VDPWR.n40 0.0627642
R1193 VDPWR.n177 VDPWR.n36 0.0624718
R1194 VDPWR.n140 VDPWR.n50 0.0612059
R1195 VDPWR.n16 VDPWR 0.0605
R1196 VDPWR.n215 VDPWR 0.0605
R1197 VDPWR VDPWR.n214 0.0605
R1198 VDPWR VDPWR.n211 0.0605
R1199 VDPWR VDPWR.n0 0.0605
R1200 VDPWR VDPWR.n233 0.0605
R1201 VDPWR.n136 VDPWR.n50 0.0599468
R1202 VDPWR.n166 VDPWR.n43 0.0577377
R1203 VDPWR.n136 VDPWR.n135 0.0571702
R1204 VDPWR.n135 VDPWR.n134 0.0555
R1205 VDPWR.n134 VDPWR.n52 0.0535722
R1206 VDPWR.n171 VDPWR.n170 0.0532395
R1207 VDPWR.n162 VDPWR.n45 0.0522
R1208 VDPWR.n88 VDPWR.n87 0.0521569
R1209 VDPWR.n130 VDPWR.n52 0.0509772
R1210 VDPWR.n130 VDPWR.n129 0.0493889
R1211 VDPWR.n187 VDPWR.n186 0.0487018
R1212 VDPWR.n129 VDPWR.n128 0.04758
R1213 VDPWR.n173 VDPWR.n172 0.0460752
R1214 VDPWR.n78 VDPWR.n75 0.045577
R1215 VDPWR.n127 VDPWR.n126 0.0448348
R1216 VDPWR.n124 VDPWR.n54 0.0427745
R1217 VDPWR.n169 VDPWR.n42 0.0419028
R1218 VDPWR.n191 VDPWR.n190 0.0415667
R1219 VDPWR.n172 VDPWR.n36 0.0413571
R1220 VDPWR.n167 VDPWR.n166 0.0410333
R1221 VDPWR.n175 VDPWR.n173 0.0408577
R1222 VDPWR.n124 VDPWR.n123 0.0408512
R1223 VDPWR.n13 VDPWR.n12 0.0405
R1224 VDPWR.n176 VDPWR.n40 0.0403491
R1225 VDPWR.n179 VDPWR.n177 0.040162
R1226 VDPWR.n179 VDPWR.n178 0.040162
R1227 VDPWR.n190 VDPWR.n29 0.0397857
R1228 VDPWR.n123 VDPWR.n122 0.0389466
R1229 VDPWR.n190 VDPWR.n189 0.0385976
R1230 VDPWR.n74 VDPWR.n73 0.0383925
R1231 VDPWR.n122 VDPWR.n56 0.0377308
R1232 VDPWR.n75 VDPWR.n74 0.0376329
R1233 VDPWR.n118 VDPWR.n56 0.0358684
R1234 VDPWR.n166 VDPWR.n165 0.0356133
R1235 VDPWR.n176 VDPWR.n175 0.0341226
R1236 VDPWR.n118 VDPWR.n117 0.0338649
R1237 VDPWR.n117 VDPWR.n116 0.0320472
R1238 VDPWR.n116 VDPWR.n58 0.0306596
R1239 VDPWR.n199 VDPWR.n13 0.0305
R1240 VDPWR.n112 VDPWR.n58 0.0288738
R1241 VDPWR.n76 VDPWR.n33 0.0282619
R1242 VDPWR.n112 VDPWR.n111 0.0271047
R1243 VDPWR.n211 VDPWR.n210 0.02675
R1244 VDPWR.n233 VDPWR.n2 0.02675
R1245 VDPWR.n111 VDPWR.n110 0.0257593
R1246 VDPWR.n228 VDPWR.n25 0.0255
R1247 VDPWR.n193 VDPWR.n192 0.0249162
R1248 VDPWR.n180 VDPWR.n38 0.0249162
R1249 VDPWR.n184 VDPWR.n38 0.0249162
R1250 VDPWR.n110 VDPWR.n60 0.0239128
R1251 VDPWR.n90 VDPWR.n66 0.02261
R1252 VDPWR.n106 VDPWR.n60 0.0222982
R1253 VDPWR.n32 VDPWR.n27 0.02162
R1254 VDPWR.n196 VDPWR.n27 0.02162
R1255 VDPWR.n183 VDPWR.n182 0.02162
R1256 VDPWR.n186 VDPWR.n185 0.0212984
R1257 VDPWR.n106 VDPWR.n105 0.0205913
R1258 VDPWR.n105 VDPWR.n104 0.018984
R1259 VDPWR.n169 VDPWR.n168 0.0188236
R1260 VDPWR.n77 VDPWR.n76 0.0182408
R1261 VDPWR.n92 VDPWR.n66 0.0179271
R1262 VDPWR.n104 VDPWR.n62 0.0176222
R1263 VDPWR.n100 VDPWR.n62 0.0160294
R1264 VDPWR.n163 VDPWR.n162 0.015852
R1265 VDPWR.n168 VDPWR.n43 0.0156247
R1266 VDPWR.n170 VDPWR.n41 0.0149236
R1267 VDPWR.n44 VDPWR.n43 0.0148367
R1268 VDPWR.n100 VDPWR.n99 0.0140385
R1269 VDPWR.n181 VDPWR.n39 0.0138871
R1270 VDPWR.n181 VDPWR.n180 0.0133938
R1271 VDPWR.n35 VDPWR.n34 0.0132264
R1272 VDPWR.n195 VDPWR.n28 0.0132264
R1273 VDPWR.n99 VDPWR.n98 0.0131847
R1274 VDPWR.n192 VDPWR.n34 0.0131568
R1275 VDPWR.n193 VDPWR.n28 0.0131568
R1276 VDPWR.n190 VDPWR.n33 0.0115
R1277 VDPWR.n98 VDPWR.n64 0.0112027
R1278 VDPWR.n174 VDPWR.n37 0.0100472
R1279 VDPWR.n178 VDPWR.n37 0.0100023
R1280 VDPWR.n94 VDPWR.n64 0.00957623
R1281 VDPWR.n94 VDPWR.n93 0.00839238
R1282 VDPWR.n214 VDPWR.n213 0.00675
R1283 VDPWR.n175 VDPWR.n174 0.00672642
R1284 VDPWR.n202 VDPWR.n201 0.00661111
R1285 VDPWR.n93 VDPWR.n92 0.00641928
R1286 VDPWR.n185 VDPWR.n37 0.00463323
R1287 VDPWR.n198 VDPWR.n18 0.003
R1288 VDPWR.n23 VDPWR.n21 0.00197617
R1289 VDPWR.n165 VDPWR.n44 0.00108355
R1290 VDPWR.n232 VDPWR.n21 0.00102381
R1291 VDPWR.n204 VDPWR.n24 0.001
R1292 VDPWR.n203 VDPWR.n24 0.001
R1293 VDPWR.n227 VDPWR.n204 0.001
R1294 VDPWR.n203 VDPWR.n23 0.001
R1295 uo_out[2].n3 uo_out[2].t2 15.0005
R1296 uo_out[2] uo_out[2].n3 12.8496
R1297 uo_out[2].n2 uo_out[2] 10.3114
R1298 uo_out[2].n2 uo_out[2].n1 9.01936
R1299 uo_out[2].n0 uo_out[2].t1 8.53421
R1300 uo_out[2].n0 uo_out[2].t0 6.13626
R1301 uo_out[2].n1 uo_out[2].n0 0.0993764
R1302 uo_out[2].n1 uo_out[2] 0.0598258
R1303 uo_out[2] uo_out[2].n2 0.0388429
R1304 uo_out[2].n3 uo_out[2] 0.02525
R1305 uo_out[0].n4 uo_out[0].n3 30.9137
R1306 uo_out[0].n5 uo_out[0].t0 18.0455
R1307 uo_out[0] uo_out[0].t1 18.0125
R1308 uo_out[0].n1 uo_out[0].t3 15.0005
R1309 uo_out[0].n2 uo_out[0].n1 9.03505
R1310 uo_out[0].n5 uo_out[0].n4 6.67645
R1311 uo_out[0].n4 uo_out[0].n0 4.90955
R1312 uo_out[0].n3 uo_out[0].n2 4.5005
R1313 uo_out[0].n0 uo_out[0].t2 3.93974
R1314 uo_out[0].n3 uo_out[0] 1.35863
R1315 uo_out[0] uo_out[0].n5 0.0885
R1316 uo_out[0].n0 uo_out[0] 0.0446962
R1317 uo_out[0].n2 uo_out[0] 0.0401
R1318 uo_out[0].n1 uo_out[0] 0.02525
R1319 uo_out[3].n2 uo_out[3] 13.4457
R1320 uo_out[3].n2 uo_out[3].n1 9.0225
R1321 uo_out[3].n0 uo_out[3].t1 8.53421
R1322 uo_out[3].n0 uo_out[3].t0 6.13626
R1323 uo_out[3].n1 uo_out[3].n0 0.11668
R1324 uo_out[3].n1 uo_out[3] 0.0425225
R1325 uo_out[3] uo_out[3].n2 0.0357
C0 ring_0/inverter_ring_0/skullfet_inverter_3.A ring_0/inverter_ring_0/skullfet_inverter_0.VDPWR 1.88662f
C1 uo_out[1] freq_divider_0.sg13g2_dfrbp_2_1.D 1.01672f
C2 m2_14237_19524# m1_14237_19524# 84.9652f
C3 ring_0/inverter_ring_0/skullfet_inverter_5.A ring_0/inverter_ring_0/skullfet_inverter_0.VDPWR 1.36774f
C4 m5_16227_32121# m6_16227_32121# 79.3164f
C5 ring_0/inverter_ring_0/skullfet_inverter_1.A ring_0/inverter_ring_0/skullfet_inverter_0.VDPWR 1.00421f
C6 m3_14237_19524# m2_14237_19524# 84.9652f
C7 m5_14237_19524# m6_14237_19524# 53.9784f
C8 m4_14237_19524# m5_14237_19524# 84.9652f
C9 uo_out[2] uo_out[3] 2.9276f
C10 ring_0/inverter_ring_0/skullfet_inverter_6.A ring_0/inverter_ring_0/skullfet_inverter_0.VDPWR 1.32654f
C11 ring_0/inverter_ring_0/skullfet_inverter_4.A ring_0/inverter_ring_0/skullfet_inverter_0.VDPWR 1.27503f
C12 uo_out[1] freq_divider_0.sg13g2_dfrbp_2_0.RESET_B 1.04892f
C13 m4_16227_32121# m5_16227_32121# 0.12485p
C14 ring_0/inverter_ring_0/skullfet_inverter_10.A ring_0/inverter_ring_0/skullfet_inverter_0.VDPWR 1.00573f
C15 m3_16227_32121# m2_16227_32121# 0.12485p
C16 m3_16227_32121# m4_16227_32121# 0.12485p
C17 freq_divider_0.sg13g2_dfrbp_2_0.RESET_B VDPWR 4.20826f
C18 ring_0/inverter_ring_0/skullfet_inverter_2.A ring_0/inverter_ring_0/skullfet_inverter_0.VDPWR 1.00886f
C19 m2_16227_32121# m1_16227_32121# 0.12485p
C20 m4_14237_19524# m3_14237_19524# 84.9652f
C21 uo_out[0] VGND 11.3962f
C22 uo_out[1] VGND 1.11045f
C23 uo_out[2] VGND 3.15045f
C24 uo_out[3] VGND 5.94477f
C25 VDPWR VGND 54.36631f
C26 ring_0/inverter_ring_0/skullfet_inverter_4.A VGND 7.56786f
C27 ring_0/inverter_ring_0/skullfet_inverter_3.A VGND 8.20672f
C28 ring_0/inverter_ring_0/skullfet_inverter_5.A VGND 8.40225f
C29 ring_0/inverter_ring_0/skullfet_inverter_2.A VGND 7.52484f
C30 ring_0/inverter_ring_0/skullfet_inverter_6.A VGND 7.74707f
C31 ring_0/inverter_ring_0/skullfet_inverter_1.A VGND 7.47326f
C32 ring_0/inverter_ring_0/skullfet_inverter_7.A VGND 7.44285f
C33 ring_0/inverter_ring_0/skullfet_inverter_0.A VGND 7.25001f
C34 ring_0/inverter_ring_0/skullfet_inverter_8.A VGND 6.76695f
C35 ring_0/inverter_ring_0/skullfet_inverter_0.Y VGND 6.64918f
C36 ring_0/inverter_ring_0/skullfet_inverter_9.A VGND 6.39759f
C37 ring_0/inverter_ring_0/skullfet_inverter_19.A VGND 6.32229f
C38 ring_0/inverter_ring_0/skullfet_inverter_10.A VGND 5.44514f
C39 ring_0/inverter_ring_0/skullfet_inverter_18.A VGND 5.42579f
C40 ring_0/inverter_ring_0/skullfet_inverter_11.A VGND 5.53877f
C41 ring_0/inverter_ring_0/skullfet_inverter_17.A VGND 5.64736f
C42 ring_0/inverter_ring_0/skullfet_inverter_12.A VGND 5.67516f
C43 ring_0/inverter_ring_0/skullfet_inverter_16.A VGND 5.62338f
C44 ring_0/inverter_ring_0/skullfet_inverter_13.A VGND 5.46725f
C45 ring_0/inverter_ring_0/skullfet_inverter_14.A VGND 5.10523f
C46 a_23219_61640# VGND 1.57954f
C47 a_19955_61640# VGND 1.58377f
C48 freq_divider_0.sg13g2_dfrbp_2_0.D VGND 1.09465f
C49 a_17075_61640# VGND 1.5798f
C50 freq_divider_0.sg13g2_dfrbp_2_0.RESET_B VGND 3.12316f
C51 ring_0/inverter_ring_0/skullfet_inverter_0.VDPWR VGND 66.63947f
.ends
