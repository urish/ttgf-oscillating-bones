* Oscillating Bones testbench (gf180mcuD, 3.3V)
*
* gf180 device models + corner setup:
.include pdk_lib.spice

* Power supply (gf180 core = 3.3V) and inputs
V1 VGND 0 0
V2 VDPWR VGND 3.3
V4 clk 0 0
V5 ena VGND 3.3
* release reset shortly after start so the divider counts:
V6 rst_n 0 PWL(0 0 12n 0 12.5n 3.3)

* DUT: the magic-extracted post-layout netlist (make spice)
.include "tt_um_oscillating_bones.spice"

x1
+ ena clk rst_n
+ VGND VGND VGND VGND VGND VGND VGND VGND
+ VGND VGND VGND VGND VGND VGND VGND VGND
+ uo_out[0] uo_out[1] uo_out[2] uo_out[3] uo_out[4] uo_out[5] uo_out[6] uo_out[7]
+ uio_out[0] uio_out[1] uio_out[2] uio_out[3] uio_out[4] uio_out[5] uio_out[6] uio_out[7]
+ uio_oe[0] uio_oe[1] uio_oe[2] uio_oe[3] uio_oe[4] uio_oe[5] uio_oe[6] uio_oe[7]
+ VGND VDPWR
+ tt_um_oscillating_bones

.tran 10p 400n uic
.option rshunt = 1.0e9

.control
run
plot "uo_out[0]" "uo_out[1]"+4 "uo_out[2]"+8 "uo_out[3]"+12
meas tran tdiff TRIG "uo_out[0]" VAL=1.65 RISE=3 TARG "uo_out[0]" VAL=1.65 RISE=4
let freq_mhz = (1 / (tdiff) / 1e6)
print freq_mhz
.endc
.end

* NOTE: for the turnkey post-layout re-simulation (extracts the hardened GDS, ties the
* std-cell wells/substrate, drives 3.3V, and reports osc_out + osc_div_2/4/8 frequencies),
* run `make sim` (scripts/sim_ring.sh). This static testbench is the gf180 template; it needs
* the magic-extracted DUT netlist to have its wells/substrate tied to VDPWR/VGND.
